simulator( 'spectre )
design(	 "/net/g/zzhou/pub/ML_HCR/simulation/hcr_ml/fulltest_closeloop/maestro/results/maestro/.tmpADEDir_zzhou/hcr_ml_fulltest_closeloop_1/hcr_ml_fulltest_closeloop_schematic_spectre/netlist/netlist")
resultsDir( "/net/g/zzhou/pub/ML_HCR/simulation/results" )
modelFile(
    '("/net/ic/pdk/tsmc180/tsmc180_cmsp007/tsmc18/../models/spectre/cmn018_assp_v1d3.scs" "tt_dio_m")
    '("/net/ic/pdk/tsmc180/tsmc180_cmsp007/tsmc18/../models/spectre/cmn018_assp_v1d3.scs" "tt_dio_3m")
    '("/net/ic/pdk/tsmc180/tsmc180_cmsp007/tsmc18/../models/spectre/cmn018_assp_v1d3.scs" "tt_rtmom")
    '("/net/ic/pdk/tsmc180/tsmc180_cmsp007/tsmc18/../models/spectre/cmn018_assp_v1d3.scs" "tt_bbmvar")
    '("/net/ic/pdk/tsmc180/tsmc180_cmsp007/tsmc18/../models/spectre/cmn018_assp_v1d3.scs" "tt_disres")
    '("/net/ic/pdk/tsmc180/tsmc180_cmsp007/tsmc18/../models/spectre/cmn018_assp_v1d3.scs" "tt")
    '("/net/ic/pdk/tsmc180/tsmc180_cmsp007/tsmc18/../models/spectre/cmn018_assp_v1d3.scs" "tt_mim")
    '("/net/ic/pdk/tsmc180/tsmc180_cmsp007/tsmc18/../models/spectre/cmn018_assp_v1d3.scs" "tt_dio_dnw")
    '("/net/ic/pdk/tsmc180/tsmc180_cmsp007/tsmc18/../models/spectre/cmn018_assp_v1d3.scs" "tt_m")
    '("/net/ic/pdk/tsmc180/tsmc180_cmsp007/tsmc18/../models/spectre/cmn018_assp_v1d3.scs" "tt_3m")
    '("/net/ic/pdk/tsmc180/tsmc180_cmsp007/tsmc18/../models/spectre/cmn018_assp_v1d3.scs" "tt_ana33")
    '("/net/ic/pdk/tsmc180/tsmc180_cmsp007/tsmc18/../models/spectre/cmn018_assp_v1d3.scs" "tt_res")
    '("/net/ic/pdk/tsmc180/tsmc180_cmsp007/tsmc18/../models/spectre/cmn018_assp_v1d3.scs" "tt_bip3")
    '("/net/ic/pdk/tsmc180/tsmc180_cmsp007/tsmc18/../models/spectre/cmn018_assp_v1d3.scs" "tt_bip")
    '("/net/ic/pdk/tsmc180/tsmc180_cmsp007/tsmc18/../models/spectre/cmn018_assp_v1d3.scs" "tt_dio3")
    '("/net/ic/pdk/tsmc180/tsmc180_cmsp007/tsmc18/../models/spectre/cmn018_assp_v1d3.scs" "tt_3v")
    '("/net/ic/pdk/tsmc180/tsmc180_cmsp007/tsmc18/../models/spectre/cmn018_assp_v1d3.scs" "tt_dio")
    '("/net/ic/pdk/tsmc180/tsmc180_cmsp007/tsmc18/../models/spectre/cmn018_assp_v1d3.scs" "tt_na")
    '("/net/ic/pdk/tsmc180/tsmc180_cmsp007/tsmc18/../models/spectre/cmn018_assp_v1d3.scs" "tt_fmom")
    '("/net/ic/pdk/tsmc180/tsmc180_cmsp007/tsmc18/../models/spectre/cmn018_assp_v1d3.scs" "tt_3vna")
)
analysis('tran ?stop "0.0018520000000000001"  ?cmin "100f"  )
desVar(      "c1" 19.0u )
desVar(      "c2" 12.0u )
desVar(      "c3" 10.0u )
desVar(      "c4" 17.0u )
desVar(      "l" 5.6u )
desVar(      "f1" 50 )
desVar(      "f10" 50 )
desVar(      "f11" 60 )
desVar(      "f12" 60 )
desVar(      "f2" 90 )
desVar(      "f3" 80 )
desVar(      "f4" 80 )
desVar(      "f5" 70 )
desVar(      "f6" 40 )
desVar(      "f7" 80 )
desVar(      "f8" 10 )
desVar(      "f9" 30 )
desVar(      "m1" 80 )
desVar(      "m10" 280 )
desVar(      "m11" 380 )
desVar(      "m12" 310 )
desVar(      "m2" 70 )
desVar(      "m3" 230 )
desVar(      "m4" 80 )
desVar(      "m5" 180 )
desVar(      "m6" 30 )
desVar(      "m7" 70 )
desVar(      "m8" 100 )
desVar(      "m9" 310 )
desVar(      "trise" 30u    )
desVar(      "cpo" 4880.0p )
desVar(      "cdr" 4n    )
desVar(      "co" 20u    )
desVar(      "ramp" 4840.0n )
desVar(      "vref" 615.0m )
desVar(      "IL" 1000.0m )
envOption(
	'termDirectionMismatch  "ignore"
	'termMismatch  "ignore"
	'analysisOrder  list("tran" "pz" "dcmatch" "stb" "envlp" "ac" "dc" "lf" "noise" "xf" "sp" "pss" "pac" "pstb" "pnoise" "pxf" "psp" "qpss" "qpac" "qpnoise" "qpxf" "qpsp" "hb" "hbac" "hbstb" "hbnoise" "hbxf" "sens" "acmatch")
)
option(	'additionalArgs  "max_minstep_nonconv=5000"
	'pzSeverity  "None"
	'noiseSeverity  "None"
	'spSeverity  "None"
	'acSeverity  "None"
	'dcOpSeverity  "None"
	'dcSeverity  "None"
	'tranSeverity  "None"
	'multithread  "on"
)
option( ?categ 'turboOpts
	'disableVddOverride  nil
	'apsplus  t
	'errorLevel  "Liberal"
)
saveOption( ?outputParamInfo nil )
saveOption( ?elementInfo nil )
saveOption( ?modelParamInfo nil )
saveOption( ?simOutputFormat "psf" )
saveOption( ?infoOptions list(list("modelParameter" "models" "rawfile" "" "" "" nil) list("element" "inst" "rawfile" "" "" "" nil) list("outputParameter" "output" "rawfile" "" "" "" nil) list("designParamVals" "parameters" "rawfile" "" "" "" nil) list("primitives" "primitives" "rawfile" "" "" "" nil) list("subckts" "subckts" "rawfile" "" "" "" nil) list("asserts" "assert" "rawfile" "" "" "" nil) list("extremeinfo" "all" "logfile" "" "yes" "" nil) list("allcap" "allcap" "file" "" "" "" nil) list("<Click_To_Add>" "none" "rawfile" "" "" "" nil) ) )
saveOption( ?saveahdlvars "selected" )
saveOption( 'currents "selected" )
saveOption( 'pwr "none" )
saveOption( 'save "selected" )
save( 'v "/vo" "/ea" )
save( 'i "/V16/MINUS" "/V14/MINUS" )
converge( 'ic "/vo" "1" )
converge( 'ic "/net023" "1" )
converge( 'ic "/net094" "1" )
converge( 'ic "/4top" "1" )
converge( 'ic "/s23" "0" )
converge( 'ic "/s1" "0" )
converge( 'ic "/vref" "0" )
converge( 'ic "/net045" "1" )
converge( 'ic "/1top" "2" )
converge( 'ic "/a" "5.5" )
converge( 'ic "/2top" "5.5" )
temp( 27 )
run()
selectResult( 'tran )

vc1 = average(clipX(vtime('tran "/vo") 0.0004 (0.0004 + VAR("ramp"))))
vc2 = average(clipX(vtime('tran "/vo") (0.0004 + (1 * VAR("ramp"))) (0.0004 + (2 * VAR("ramp")))))
vc3 = average(clipX(vtime('tran "/vo") (0.0004 + (2 * VAR("ramp"))) (0.0004 + (3 * VAR("ramp")))))
vc4 = average(clipX(vtime('tran "/vo") (0.0004 + (3 * VAR("ramp"))) (0.0004 + (4 * VAR("ramp")))))

ea1 = average(clipX(vtime('tran "/ea") 0.0004 (0.0004 + VAR("ramp"))))
ea2 = average(clipX(vtime('tran "/ea") (0.0004 + (1 * VAR("ramp"))) (0.0004 + (2 * VAR("ramp")))))
ea3 = average(clipX(vtime('tran "/ea") (0.0004 + (2 * VAR("ramp"))) (0.0004 + (3 * VAR("ramp")))))
ea4 = average(clipX(vtime('tran "/ea") (0.0004 + (3 * VAR("ramp"))) (0.0004 + (4 * VAR("ramp")))))

ripple = peakToPeak(clipX(vtime('tran "/vo") (0.0018520000000000001 - (10 * VAR("ramp"))) 0.0018520000000000001))
Vo = average(clipX(vtime('tran "/vo") (0.0018520000000000001 - (10 * VAR("ramp"))) 0.0018520000000000001))
Pout = ((Vo * VAR("IL")) + ((Vo * Vo) / 1000))
Iin = average(clipX(IT("/V16/MINUS") (0.0018520000000000001 - (10 * VAR("ramp"))) 0.0018520000000000001))
Pin = (Iin * 5.5)
Id = average(clipX(IT("/V14/MINUS") (0.0018520000000000001 - (10 * VAR("ramp"))) 0.0018520000000000001))
Pd = (Id * 1.8)
eff = ((Pout / (Pin + Pd)) * 100)
Imin = ymin(clipX(IT("/V16/MINUS") (0.0018520000000000001 - (10 * VAR("ramp"))) 0.0018520000000000001))

port=outfile("/net/g/zzhou/pub/ML_HCR/hcrtestresult.txt" "a")
ocnPrint(?output port eff Vo ripple vc1 vc2 vc3 vc4 vc5 vc6 vc7 vc8 vc9 vc10 vc11 vc12 vc13 vc14 vc15 vc16 vc17 vc18 vc19 vc20 vc21 vc22 vc23 vc24 vc25 vc26 vc27 vc28 vc29 vc30 vc31 vc32 vc33 vc34 vc35 vc36 vc37 vc38 vc39 vc40 vc41 vc42 vc43 vc44 vc45 vc46 vc47 vc48 vc49 vc50 vc51 vc52 vc53 vc54 vc55 vc56 vc57 vc58 vc59 vc60 vc61 vc62 vc63 vc64 vc65 vc66 vc67 vc68 vc69 vc70 vc71 vc72 vc73 vc74 vc75 vc76 vc77 vc78 vc79 vc80 vc81 vc82 vc83 vc84 vc85 vc86 vc87 vc88 vc89 vc90 vc91 vc92 vc93 vc94 vc95 vc96 vc97 vc98 vc99 vc100 vc101 vc102 vc103 vc104 vc105 vc106 vc107 vc108 vc109 vc110 vc111 vc112 vc113 vc114 vc115 vc116 vc117 vc118 vc119 vc120 vc121 vc122 vc123 vc124 vc125 vc126 vc127 vc128 vc129 vc130 vc131 vc132 vc133 vc134 vc135 vc136 vc137 vc138 vc139 vc140 vc141 vc142 vc143 vc144 vc145 vc146 vc147 vc148 vc149 vc150 vc151 vc152 vc153 vc154 vc155 vc156 vc157 vc158 vc159 vc160 vc161 vc162 vc163 vc164 vc165 vc166 vc167 vc168 vc169 vc170 vc171 vc172 vc173 vc174 vc175 vc176 vc177 vc178 vc179 vc180 vc181 vc182 vc183 vc184 vc185 vc186 vc187 vc188 vc189 vc190 vc191 vc192 vc193 vc194 vc195 vc196 vc197 vc198 vc199 vc200 vc201 vc202 vc203 vc204 vc205 vc206 vc207 vc208 vc209 vc210 vc211 vc212 vc213 vc214 vc215 vc216 vc217 vc218 vc219 vc220 vc221 vc222 vc223 vc224 vc225 vc226 vc227 vc228 vc229 vc230 vc231 vc232 vc233 vc234 vc235 vc236 vc237 vc238 vc239 vc240 vc241 vc242 vc243 vc244 vc245 vc246 vc247 vc248 vc249 vc250 vc251 vc252 vc253 vc254 vc255 vc256 vc257 vc258 vc259 vc260 vc261 vc262 vc263 vc264 vc265 vc266 vc267 vc268 vc269 vc270 vc271 vc272 vc273 vc274 vc275 vc276 vc277 vc278 vc279 vc280 vc281 vc282 vc283 vc284 vc285 vc286 vc287 vc288 vc289 vc290 vc291 vc292 vc293 vc294 vc295 vc296 vc297 vc298 vc299 vc300 ea1 ea2 ea3 ea4 ea5 ea6 ea7 ea8 ea9 ea10 ea11 ea12 ea13 ea14 ea15 ea16 ea17 ea18 ea19 ea20 ea21 ea22 ea23 ea24 ea25 ea26 ea27 ea28 ea29 ea30 ea31 ea32 ea33 ea34 ea35 ea36 ea37 ea38 ea39 ea40 ea41 ea42 ea43 ea44 ea45 ea46 ea47 ea48 ea49 ea50 ea51 ea52 ea53 ea54 ea55 ea56 ea57 ea58 ea59 ea60 ea61 ea62 ea63 ea64 ea65 ea66 ea67 ea68 ea69 ea70 ea71 ea72 ea73 ea74 ea75 ea76 ea77 ea78 ea79 ea80 ea81 ea82 ea83 ea84 ea85 ea86 ea87 ea88 ea89 ea90 ea91 ea92 ea93 ea94 ea95 ea96 ea97 ea98 ea99 ea100 ea101 ea102 ea103 ea104 ea105 ea106 ea107 ea108 ea109 ea110 ea111 ea112 ea113 ea114 ea115 ea116 ea117 ea118 ea119 ea120 ea121 ea122 ea123 ea124 ea125 ea126 ea127 ea128 ea129 ea130 ea131 ea132 ea133 ea134 ea135 ea136 ea137 ea138 ea139 ea140 ea141 ea142 ea143 ea144 ea145 ea146 ea147 ea148 ea149 ea150 ea151 ea152 ea153 ea154 ea155 ea156 ea157 ea158 ea159 ea160 ea161 ea162 ea163 ea164 ea165 ea166 ea167 ea168 ea169 ea170 ea171 ea172 ea173 ea174 ea175 ea176 ea177 ea178 ea179 ea180 ea181 ea182 ea183 ea184 ea185 ea186 ea187 ea188 ea189 ea190 ea191 ea192 ea193 ea194 ea195 ea196 ea197 ea198 ea199 ea200 ea201 ea202 ea203 ea204 ea205 ea206 ea207 ea208 ea209 ea210 ea211 ea212 ea213 ea214 ea215 ea216 ea217 ea218 ea219 ea220 ea221 ea222 ea223 ea224 ea225 ea226 ea227 ea228 ea229 ea230 ea231 ea232 ea233 ea234 ea235 ea236 ea237 ea238 ea239 ea240 ea241 ea242 ea243 ea244 ea245 ea246 ea247 ea248 ea249 ea250 ea251 ea252 ea253 ea254 ea255 ea256 ea257 ea258 ea259 ea260 ea261 ea262 ea263 ea264 ea265 ea266 ea267 ea268 ea269 ea270 ea271 ea272 ea273 ea274 ea275 ea276 ea277 ea278 ea279 ea280 ea281 ea282 ea283 ea284 ea285 ea286 ea287 ea288 ea289 ea290 ea291 ea292 ea293 ea294 ea295 ea296 ea297 ea298 ea299 ea300 Imin)
close(port)
exit()
ocnCloseSession()
