simulator( 'spectre )
design(	 "/net/g/zzhou/pub/ML_HCR/simulation/hcr_ml/fulltest_closeloop/maestro/results/maestro/.tmpADEDir_zzhou/hcr_ml_fulltest_closeloop_1/hcr_ml_fulltest_closeloop_schematic_spectre/netlist/netlist")
resultsDir( "/net/g/zzhou/pub/ML_HCR/simulation/results" )
modelFile(
    '("/net/ic/pdk/tsmc180/tsmc180_cmsp007/tsmc18/../models/spectre/cmn018_assp_v1d3.scs" "tt_dio_m")
    '("/net/ic/pdk/tsmc180/tsmc180_cmsp007/tsmc18/../models/spectre/cmn018_assp_v1d3.scs" "tt_dio_3m")
    '("/net/ic/pdk/tsmc180/tsmc180_cmsp007/tsmc18/../models/spectre/cmn018_assp_v1d3.scs" "tt_rtmom")
    '("/net/ic/pdk/tsmc180/tsmc180_cmsp007/tsmc18/../models/spectre/cmn018_assp_v1d3.scs" "tt_bbmvar")
    '("/net/ic/pdk/tsmc180/tsmc180_cmsp007/tsmc18/../models/spectre/cmn018_assp_v1d3.scs" "tt_disres")
    '("/net/ic/pdk/tsmc180/tsmc180_cmsp007/tsmc18/../models/spectre/cmn018_assp_v1d3.scs" "tt")
    '("/net/ic/pdk/tsmc180/tsmc180_cmsp007/tsmc18/../models/spectre/cmn018_assp_v1d3.scs" "tt_mim")
    '("/net/ic/pdk/tsmc180/tsmc180_cmsp007/tsmc18/../models/spectre/cmn018_assp_v1d3.scs" "tt_dio_dnw")
    '("/net/ic/pdk/tsmc180/tsmc180_cmsp007/tsmc18/../models/spectre/cmn018_assp_v1d3.scs" "tt_m")
    '("/net/ic/pdk/tsmc180/tsmc180_cmsp007/tsmc18/../models/spectre/cmn018_assp_v1d3.scs" "tt_3m")
    '("/net/ic/pdk/tsmc180/tsmc180_cmsp007/tsmc18/../models/spectre/cmn018_assp_v1d3.scs" "tt_ana33")
    '("/net/ic/pdk/tsmc180/tsmc180_cmsp007/tsmc18/../models/spectre/cmn018_assp_v1d3.scs" "tt_res")
    '("/net/ic/pdk/tsmc180/tsmc180_cmsp007/tsmc18/../models/spectre/cmn018_assp_v1d3.scs" "tt_bip3")
    '("/net/ic/pdk/tsmc180/tsmc180_cmsp007/tsmc18/../models/spectre/cmn018_assp_v1d3.scs" "tt_bip")
    '("/net/ic/pdk/tsmc180/tsmc180_cmsp007/tsmc18/../models/spectre/cmn018_assp_v1d3.scs" "tt_dio3")
    '("/net/ic/pdk/tsmc180/tsmc180_cmsp007/tsmc18/../models/spectre/cmn018_assp_v1d3.scs" "tt_3v")
    '("/net/ic/pdk/tsmc180/tsmc180_cmsp007/tsmc18/../models/spectre/cmn018_assp_v1d3.scs" "tt_dio")
    '("/net/ic/pdk/tsmc180/tsmc180_cmsp007/tsmc18/../models/spectre/cmn018_assp_v1d3.scs" "tt_na")
    '("/net/ic/pdk/tsmc180/tsmc180_cmsp007/tsmc18/../models/spectre/cmn018_assp_v1d3.scs" "tt_fmom")
    '("/net/ic/pdk/tsmc180/tsmc180_cmsp007/tsmc18/../models/spectre/cmn018_assp_v1d3.scs" "tt_3vna")
)
analysis('tran ?stop "0.001336"  ?cmin "100f"  )
desVar(      "c1" 9.4u )
desVar(      "c2" 19.0u )
desVar(      "c3" 15.0u )
desVar(      "c4" 12.0u )
desVar(      "l" 1.8u )
desVar(      "f1" 20 )
desVar(      "f10" 20 )
desVar(      "f11" 25 )
desVar(      "f12" 25 )
desVar(      "f2" 25 )
desVar(      "f3" 15 )
desVar(      "f4" 15 )
desVar(      "f5" 25 )
desVar(      "f6" 15 )
desVar(      "f7" 25 )
desVar(      "f8" 20 )
desVar(      "f9" 15 )
desVar(      "m1" 56 )
desVar(      "m10" 62 )
desVar(      "m11" 53 )
desVar(      "m12" 174 )
desVar(      "m2" 110 )
desVar(      "m3" 147 )
desVar(      "m4" 41 )
desVar(      "m5" 174 )
desVar(      "m6" 164 )
desVar(      "m7" 92 )
desVar(      "m8" 86 )
desVar(      "m9" 92 )
desVar(      "trise" 30u    )
desVar(      "cpo" 3000.0p )
desVar(      "cdr" 4n    )
desVar(      "co" 20u    )
desVar(      "ramp" 1040.0n )
desVar(      "vref" 590.0m )
desVar(      "IL" 1000.0m )
envOption(
	'termDirectionMismatch  "ignore"
	'termMismatch  "ignore"
	'analysisOrder  list("tran" "pz" "dcmatch" "stb" "envlp" "ac" "dc" "lf" "noise" "xf" "sp" "pss" "pac" "pstb" "pnoise" "pxf" "psp" "qpss" "qpac" "qpnoise" "qpxf" "qpsp" "hb" "hbac" "hbstb" "hbnoise" "hbxf" "sens" "acmatch")
)
option(	'additionalArgs  "max_minstep_nonconv=5000"
	'pzSeverity  "None"
	'noiseSeverity  "None"
	'spSeverity  "None"
	'acSeverity  "None"
	'dcOpSeverity  "None"
	'dcSeverity  "None"
	'tranSeverity  "None"
	'multithread  "on"
)
option( ?categ 'turboOpts
	'disableVddOverride  nil
	'apsplus  t
	'errorLevel  "Liberal"
)
saveOption( ?outputParamInfo nil )
saveOption( ?elementInfo nil )
saveOption( ?modelParamInfo nil )
saveOption( ?simOutputFormat "psf" )
saveOption( ?infoOptions list(list("modelParameter" "models" "rawfile" "" "" "" nil) list("element" "inst" "rawfile" "" "" "" nil) list("outputParameter" "output" "rawfile" "" "" "" nil) list("designParamVals" "parameters" "rawfile" "" "" "" nil) list("primitives" "primitives" "rawfile" "" "" "" nil) list("subckts" "subckts" "rawfile" "" "" "" nil) list("asserts" "assert" "rawfile" "" "" "" nil) list("extremeinfo" "all" "logfile" "" "yes" "" nil) list("allcap" "allcap" "file" "" "" "" nil) list("<Click_To_Add>" "none" "rawfile" "" "" "" nil) ) )
saveOption( ?saveahdlvars "selected" )
saveOption( 'currents "selected" )
saveOption( 'pwr "none" )
saveOption( 'save "selected" )
save( 'v "/vo" "/ea" )
save( 'i "/V16/MINUS" "/V14/MINUS" )
converge( 'ic "/vo" "1" )
converge( 'ic "/net023" "1" )
converge( 'ic "/net094" "1" )
converge( 'ic "/4top" "1" )
converge( 'ic "/s23" "0" )
converge( 'ic "/s1" "0" )
converge( 'ic "/vref" "0" )
converge( 'ic "/net045" "1" )
converge( 'ic "/1top" "2" )
converge( 'ic "/a" "5.5" )
converge( 'ic "/2top" "5.5" )
temp( 27 )
run()
selectResult( 'tran )

vc1 = average(clipX(vtime('tran "/vo") (0.0004 + (0 * VAR("ramp"))) (0.0004 + (3 * VAR("ramp")))))
vc2 = average(clipX(vtime('tran "/vo") (0.0004 + (3 * VAR("ramp"))) (0.0004 + (6 * VAR("ramp")))))
vc3 = average(clipX(vtime('tran "/vo") (0.0004 + (6 * VAR("ramp"))) (0.0004 + (9 * VAR("ramp")))))
vc4 = average(clipX(vtime('tran "/vo") (0.0004 + (9 * VAR("ramp"))) (0.0004 + (12 * VAR("ramp")))))
vc5 = average(clipX(vtime('tran "/vo") (0.0004 + (12 * VAR("ramp"))) (0.0004 + (15 * VAR("ramp")))))
vc6 = average(clipX(vtime('tran "/vo") (0.0004 + (15 * VAR("ramp"))) (0.0004 + (18 * VAR("ramp")))))
vc7 = average(clipX(vtime('tran "/vo") (0.0004 + (18 * VAR("ramp"))) (0.0004 + (21 * VAR("ramp")))))
vc8 = average(clipX(vtime('tran "/vo") (0.0004 + (21 * VAR("ramp"))) (0.0004 + (24 * VAR("ramp")))))
vc9 = average(clipX(vtime('tran "/vo") (0.0004 + (24 * VAR("ramp"))) (0.0004 + (27 * VAR("ramp")))))
vc10 = average(clipX(vtime('tran "/vo") (0.0004 + (27 * VAR("ramp"))) (0.0004 + (30 * VAR("ramp")))))
vc11 = average(clipX(vtime('tran "/vo") (0.0004 + (30 * VAR("ramp"))) (0.0004 + (33 * VAR("ramp")))))
vc12 = average(clipX(vtime('tran "/vo") (0.0004 + (33 * VAR("ramp"))) (0.0004 + (36 * VAR("ramp")))))
vc13 = average(clipX(vtime('tran "/vo") (0.0004 + (36 * VAR("ramp"))) (0.0004 + (39 * VAR("ramp")))))
vc14 = average(clipX(vtime('tran "/vo") (0.0004 + (39 * VAR("ramp"))) (0.0004 + (42 * VAR("ramp")))))
vc15 = average(clipX(vtime('tran "/vo") (0.0004 + (42 * VAR("ramp"))) (0.0004 + (45 * VAR("ramp")))))
vc16 = average(clipX(vtime('tran "/vo") (0.0004 + (45 * VAR("ramp"))) (0.0004 + (48 * VAR("ramp")))))
vc17 = average(clipX(vtime('tran "/vo") (0.0004 + (48 * VAR("ramp"))) (0.0004 + (51 * VAR("ramp")))))
vc18 = average(clipX(vtime('tran "/vo") (0.0004 + (51 * VAR("ramp"))) (0.0004 + (54 * VAR("ramp")))))
vc19 = average(clipX(vtime('tran "/vo") (0.0004 + (54 * VAR("ramp"))) (0.0004 + (57 * VAR("ramp")))))
vc20 = average(clipX(vtime('tran "/vo") (0.0004 + (57 * VAR("ramp"))) (0.0004 + (60 * VAR("ramp")))))
vc21 = average(clipX(vtime('tran "/vo") (0.0004 + (60 * VAR("ramp"))) (0.0004 + (63 * VAR("ramp")))))
vc22 = average(clipX(vtime('tran "/vo") (0.0004 + (63 * VAR("ramp"))) (0.0004 + (66 * VAR("ramp")))))
vc23 = average(clipX(vtime('tran "/vo") (0.0004 + (66 * VAR("ramp"))) (0.0004 + (69 * VAR("ramp")))))
vc24 = average(clipX(vtime('tran "/vo") (0.0004 + (69 * VAR("ramp"))) (0.0004 + (72 * VAR("ramp")))))
vc25 = average(clipX(vtime('tran "/vo") (0.0004 + (72 * VAR("ramp"))) (0.0004 + (75 * VAR("ramp")))))
vc26 = average(clipX(vtime('tran "/vo") (0.0004 + (75 * VAR("ramp"))) (0.0004 + (78 * VAR("ramp")))))
vc27 = average(clipX(vtime('tran "/vo") (0.0004 + (78 * VAR("ramp"))) (0.0004 + (81 * VAR("ramp")))))
vc28 = average(clipX(vtime('tran "/vo") (0.0004 + (81 * VAR("ramp"))) (0.0004 + (84 * VAR("ramp")))))
vc29 = average(clipX(vtime('tran "/vo") (0.0004 + (84 * VAR("ramp"))) (0.0004 + (87 * VAR("ramp")))))
vc30 = average(clipX(vtime('tran "/vo") (0.0004 + (87 * VAR("ramp"))) (0.0004 + (90 * VAR("ramp")))))
vc31 = average(clipX(vtime('tran "/vo") (0.0004 + (90 * VAR("ramp"))) (0.0004 + (93 * VAR("ramp")))))
vc32 = average(clipX(vtime('tran "/vo") (0.0004 + (93 * VAR("ramp"))) (0.0004 + (96 * VAR("ramp")))))
vc33 = average(clipX(vtime('tran "/vo") (0.0004 + (96 * VAR("ramp"))) (0.0004 + (99 * VAR("ramp")))))
vc34 = average(clipX(vtime('tran "/vo") (0.0004 + (99 * VAR("ramp"))) (0.0004 + (102 * VAR("ramp")))))
vc35 = average(clipX(vtime('tran "/vo") (0.0004 + (102 * VAR("ramp"))) (0.0004 + (105 * VAR("ramp")))))
vc36 = average(clipX(vtime('tran "/vo") (0.0004 + (105 * VAR("ramp"))) (0.0004 + (108 * VAR("ramp")))))
vc37 = average(clipX(vtime('tran "/vo") (0.0004 + (108 * VAR("ramp"))) (0.0004 + (111 * VAR("ramp")))))
vc38 = average(clipX(vtime('tran "/vo") (0.0004 + (111 * VAR("ramp"))) (0.0004 + (114 * VAR("ramp")))))
vc39 = average(clipX(vtime('tran "/vo") (0.0004 + (114 * VAR("ramp"))) (0.0004 + (117 * VAR("ramp")))))
vc40 = average(clipX(vtime('tran "/vo") (0.0004 + (117 * VAR("ramp"))) (0.0004 + (120 * VAR("ramp")))))
vc41 = average(clipX(vtime('tran "/vo") (0.0004 + (120 * VAR("ramp"))) (0.0004 + (123 * VAR("ramp")))))
vc42 = average(clipX(vtime('tran "/vo") (0.0004 + (123 * VAR("ramp"))) (0.0004 + (126 * VAR("ramp")))))
vc43 = average(clipX(vtime('tran "/vo") (0.0004 + (126 * VAR("ramp"))) (0.0004 + (129 * VAR("ramp")))))
vc44 = average(clipX(vtime('tran "/vo") (0.0004 + (129 * VAR("ramp"))) (0.0004 + (132 * VAR("ramp")))))
vc45 = average(clipX(vtime('tran "/vo") (0.0004 + (132 * VAR("ramp"))) (0.0004 + (135 * VAR("ramp")))))
vc46 = average(clipX(vtime('tran "/vo") (0.0004 + (135 * VAR("ramp"))) (0.0004 + (138 * VAR("ramp")))))
vc47 = average(clipX(vtime('tran "/vo") (0.0004 + (138 * VAR("ramp"))) (0.0004 + (141 * VAR("ramp")))))
vc48 = average(clipX(vtime('tran "/vo") (0.0004 + (141 * VAR("ramp"))) (0.0004 + (144 * VAR("ramp")))))
vc49 = average(clipX(vtime('tran "/vo") (0.0004 + (144 * VAR("ramp"))) (0.0004 + (147 * VAR("ramp")))))
vc50 = average(clipX(vtime('tran "/vo") (0.0004 + (147 * VAR("ramp"))) (0.0004 + (150 * VAR("ramp")))))
vc51 = average(clipX(vtime('tran "/vo") (0.0004 + (150 * VAR("ramp"))) (0.0004 + (153 * VAR("ramp")))))
vc52 = average(clipX(vtime('tran "/vo") (0.0004 + (153 * VAR("ramp"))) (0.0004 + (156 * VAR("ramp")))))
vc53 = average(clipX(vtime('tran "/vo") (0.0004 + (156 * VAR("ramp"))) (0.0004 + (159 * VAR("ramp")))))
vc54 = average(clipX(vtime('tran "/vo") (0.0004 + (159 * VAR("ramp"))) (0.0004 + (162 * VAR("ramp")))))
vc55 = average(clipX(vtime('tran "/vo") (0.0004 + (162 * VAR("ramp"))) (0.0004 + (165 * VAR("ramp")))))
vc56 = average(clipX(vtime('tran "/vo") (0.0004 + (165 * VAR("ramp"))) (0.0004 + (168 * VAR("ramp")))))
vc57 = average(clipX(vtime('tran "/vo") (0.0004 + (168 * VAR("ramp"))) (0.0004 + (171 * VAR("ramp")))))
vc58 = average(clipX(vtime('tran "/vo") (0.0004 + (171 * VAR("ramp"))) (0.0004 + (174 * VAR("ramp")))))
vc59 = average(clipX(vtime('tran "/vo") (0.0004 + (174 * VAR("ramp"))) (0.0004 + (177 * VAR("ramp")))))
vc60 = average(clipX(vtime('tran "/vo") (0.0004 + (177 * VAR("ramp"))) (0.0004 + (180 * VAR("ramp")))))
vc61 = average(clipX(vtime('tran "/vo") (0.0004 + (180 * VAR("ramp"))) (0.0004 + (183 * VAR("ramp")))))
vc62 = average(clipX(vtime('tran "/vo") (0.0004 + (183 * VAR("ramp"))) (0.0004 + (186 * VAR("ramp")))))
vc63 = average(clipX(vtime('tran "/vo") (0.0004 + (186 * VAR("ramp"))) (0.0004 + (189 * VAR("ramp")))))
vc64 = average(clipX(vtime('tran "/vo") (0.0004 + (189 * VAR("ramp"))) (0.0004 + (192 * VAR("ramp")))))
vc65 = average(clipX(vtime('tran "/vo") (0.0004 + (192 * VAR("ramp"))) (0.0004 + (195 * VAR("ramp")))))
vc66 = average(clipX(vtime('tran "/vo") (0.0004 + (195 * VAR("ramp"))) (0.0004 + (198 * VAR("ramp")))))
vc67 = average(clipX(vtime('tran "/vo") (0.0004 + (198 * VAR("ramp"))) (0.0004 + (201 * VAR("ramp")))))
vc68 = average(clipX(vtime('tran "/vo") (0.0004 + (201 * VAR("ramp"))) (0.0004 + (204 * VAR("ramp")))))
vc69 = average(clipX(vtime('tran "/vo") (0.0004 + (204 * VAR("ramp"))) (0.0004 + (207 * VAR("ramp")))))
vc70 = average(clipX(vtime('tran "/vo") (0.0004 + (207 * VAR("ramp"))) (0.0004 + (210 * VAR("ramp")))))
vc71 = average(clipX(vtime('tran "/vo") (0.0004 + (210 * VAR("ramp"))) (0.0004 + (213 * VAR("ramp")))))
vc72 = average(clipX(vtime('tran "/vo") (0.0004 + (213 * VAR("ramp"))) (0.0004 + (216 * VAR("ramp")))))
vc73 = average(clipX(vtime('tran "/vo") (0.0004 + (216 * VAR("ramp"))) (0.0004 + (219 * VAR("ramp")))))
vc74 = average(clipX(vtime('tran "/vo") (0.0004 + (219 * VAR("ramp"))) (0.0004 + (222 * VAR("ramp")))))
vc75 = average(clipX(vtime('tran "/vo") (0.0004 + (222 * VAR("ramp"))) (0.0004 + (225 * VAR("ramp")))))
vc76 = average(clipX(vtime('tran "/vo") (0.0004 + (225 * VAR("ramp"))) (0.0004 + (228 * VAR("ramp")))))
vc77 = average(clipX(vtime('tran "/vo") (0.0004 + (228 * VAR("ramp"))) (0.0004 + (231 * VAR("ramp")))))
vc78 = average(clipX(vtime('tran "/vo") (0.0004 + (231 * VAR("ramp"))) (0.0004 + (234 * VAR("ramp")))))
vc79 = average(clipX(vtime('tran "/vo") (0.0004 + (234 * VAR("ramp"))) (0.0004 + (237 * VAR("ramp")))))
vc80 = average(clipX(vtime('tran "/vo") (0.0004 + (237 * VAR("ramp"))) (0.0004 + (240 * VAR("ramp")))))
vc81 = average(clipX(vtime('tran "/vo") (0.0004 + (240 * VAR("ramp"))) (0.0004 + (243 * VAR("ramp")))))
vc82 = average(clipX(vtime('tran "/vo") (0.0004 + (243 * VAR("ramp"))) (0.0004 + (246 * VAR("ramp")))))
vc83 = average(clipX(vtime('tran "/vo") (0.0004 + (246 * VAR("ramp"))) (0.0004 + (249 * VAR("ramp")))))
vc84 = average(clipX(vtime('tran "/vo") (0.0004 + (249 * VAR("ramp"))) (0.0004 + (252 * VAR("ramp")))))
vc85 = average(clipX(vtime('tran "/vo") (0.0004 + (252 * VAR("ramp"))) (0.0004 + (255 * VAR("ramp")))))
vc86 = average(clipX(vtime('tran "/vo") (0.0004 + (255 * VAR("ramp"))) (0.0004 + (258 * VAR("ramp")))))
vc87 = average(clipX(vtime('tran "/vo") (0.0004 + (258 * VAR("ramp"))) (0.0004 + (261 * VAR("ramp")))))
vc88 = average(clipX(vtime('tran "/vo") (0.0004 + (261 * VAR("ramp"))) (0.0004 + (264 * VAR("ramp")))))
vc89 = average(clipX(vtime('tran "/vo") (0.0004 + (264 * VAR("ramp"))) (0.0004 + (267 * VAR("ramp")))))
vc90 = average(clipX(vtime('tran "/vo") (0.0004 + (267 * VAR("ramp"))) (0.0004 + (270 * VAR("ramp")))))
vc91 = average(clipX(vtime('tran "/vo") (0.0004 + (270 * VAR("ramp"))) (0.0004 + (273 * VAR("ramp")))))
vc92 = average(clipX(vtime('tran "/vo") (0.0004 + (273 * VAR("ramp"))) (0.0004 + (276 * VAR("ramp")))))
vc93 = average(clipX(vtime('tran "/vo") (0.0004 + (276 * VAR("ramp"))) (0.0004 + (279 * VAR("ramp")))))
vc94 = average(clipX(vtime('tran "/vo") (0.0004 + (279 * VAR("ramp"))) (0.0004 + (282 * VAR("ramp")))))
vc95 = average(clipX(vtime('tran "/vo") (0.0004 + (282 * VAR("ramp"))) (0.0004 + (285 * VAR("ramp")))))
vc96 = average(clipX(vtime('tran "/vo") (0.0004 + (285 * VAR("ramp"))) (0.0004 + (288 * VAR("ramp")))))
vc97 = average(clipX(vtime('tran "/vo") (0.0004 + (288 * VAR("ramp"))) (0.0004 + (291 * VAR("ramp")))))
vc98 = average(clipX(vtime('tran "/vo") (0.0004 + (291 * VAR("ramp"))) (0.0004 + (294 * VAR("ramp")))))
vc99 = average(clipX(vtime('tran "/vo") (0.0004 + (294 * VAR("ramp"))) (0.0004 + (297 * VAR("ramp")))))
vc100 = average(clipX(vtime('tran "/vo") (0.0004 + (297 * VAR("ramp"))) (0.0004 + (300 * VAR("ramp")))))
vc101 = average(clipX(vtime('tran "/vo") (0.0004 + (300 * VAR("ramp"))) (0.0004 + (303 * VAR("ramp")))))
vc102 = average(clipX(vtime('tran "/vo") (0.0004 + (303 * VAR("ramp"))) (0.0004 + (306 * VAR("ramp")))))
vc103 = average(clipX(vtime('tran "/vo") (0.0004 + (306 * VAR("ramp"))) (0.0004 + (309 * VAR("ramp")))))
vc104 = average(clipX(vtime('tran "/vo") (0.0004 + (309 * VAR("ramp"))) (0.0004 + (312 * VAR("ramp")))))
vc105 = average(clipX(vtime('tran "/vo") (0.0004 + (312 * VAR("ramp"))) (0.0004 + (315 * VAR("ramp")))))
vc106 = average(clipX(vtime('tran "/vo") (0.0004 + (315 * VAR("ramp"))) (0.0004 + (318 * VAR("ramp")))))
vc107 = average(clipX(vtime('tran "/vo") (0.0004 + (318 * VAR("ramp"))) (0.0004 + (321 * VAR("ramp")))))
vc108 = average(clipX(vtime('tran "/vo") (0.0004 + (321 * VAR("ramp"))) (0.0004 + (324 * VAR("ramp")))))
vc109 = average(clipX(vtime('tran "/vo") (0.0004 + (324 * VAR("ramp"))) (0.0004 + (327 * VAR("ramp")))))
vc110 = average(clipX(vtime('tran "/vo") (0.0004 + (327 * VAR("ramp"))) (0.0004 + (330 * VAR("ramp")))))
vc111 = average(clipX(vtime('tran "/vo") (0.0004 + (330 * VAR("ramp"))) (0.0004 + (333 * VAR("ramp")))))
vc112 = average(clipX(vtime('tran "/vo") (0.0004 + (333 * VAR("ramp"))) (0.0004 + (336 * VAR("ramp")))))
vc113 = average(clipX(vtime('tran "/vo") (0.0004 + (336 * VAR("ramp"))) (0.0004 + (339 * VAR("ramp")))))
vc114 = average(clipX(vtime('tran "/vo") (0.0004 + (339 * VAR("ramp"))) (0.0004 + (342 * VAR("ramp")))))
vc115 = average(clipX(vtime('tran "/vo") (0.0004 + (342 * VAR("ramp"))) (0.0004 + (345 * VAR("ramp")))))
vc116 = average(clipX(vtime('tran "/vo") (0.0004 + (345 * VAR("ramp"))) (0.0004 + (348 * VAR("ramp")))))
vc117 = average(clipX(vtime('tran "/vo") (0.0004 + (348 * VAR("ramp"))) (0.0004 + (351 * VAR("ramp")))))
vc118 = average(clipX(vtime('tran "/vo") (0.0004 + (351 * VAR("ramp"))) (0.0004 + (354 * VAR("ramp")))))
vc119 = average(clipX(vtime('tran "/vo") (0.0004 + (354 * VAR("ramp"))) (0.0004 + (357 * VAR("ramp")))))
vc120 = average(clipX(vtime('tran "/vo") (0.0004 + (357 * VAR("ramp"))) (0.0004 + (360 * VAR("ramp")))))
vc121 = average(clipX(vtime('tran "/vo") (0.0004 + (360 * VAR("ramp"))) (0.0004 + (363 * VAR("ramp")))))
vc122 = average(clipX(vtime('tran "/vo") (0.0004 + (363 * VAR("ramp"))) (0.0004 + (366 * VAR("ramp")))))
vc123 = average(clipX(vtime('tran "/vo") (0.0004 + (366 * VAR("ramp"))) (0.0004 + (369 * VAR("ramp")))))
vc124 = average(clipX(vtime('tran "/vo") (0.0004 + (369 * VAR("ramp"))) (0.0004 + (372 * VAR("ramp")))))
vc125 = average(clipX(vtime('tran "/vo") (0.0004 + (372 * VAR("ramp"))) (0.0004 + (375 * VAR("ramp")))))
vc126 = average(clipX(vtime('tran "/vo") (0.0004 + (375 * VAR("ramp"))) (0.0004 + (378 * VAR("ramp")))))
vc127 = average(clipX(vtime('tran "/vo") (0.0004 + (378 * VAR("ramp"))) (0.0004 + (381 * VAR("ramp")))))
vc128 = average(clipX(vtime('tran "/vo") (0.0004 + (381 * VAR("ramp"))) (0.0004 + (384 * VAR("ramp")))))
vc129 = average(clipX(vtime('tran "/vo") (0.0004 + (384 * VAR("ramp"))) (0.0004 + (387 * VAR("ramp")))))
vc130 = average(clipX(vtime('tran "/vo") (0.0004 + (387 * VAR("ramp"))) (0.0004 + (390 * VAR("ramp")))))
vc131 = average(clipX(vtime('tran "/vo") (0.0004 + (390 * VAR("ramp"))) (0.0004 + (393 * VAR("ramp")))))
vc132 = average(clipX(vtime('tran "/vo") (0.0004 + (393 * VAR("ramp"))) (0.0004 + (396 * VAR("ramp")))))
vc133 = average(clipX(vtime('tran "/vo") (0.0004 + (396 * VAR("ramp"))) (0.0004 + (399 * VAR("ramp")))))
vc134 = average(clipX(vtime('tran "/vo") (0.0004 + (399 * VAR("ramp"))) (0.0004 + (402 * VAR("ramp")))))
vc135 = average(clipX(vtime('tran "/vo") (0.0004 + (402 * VAR("ramp"))) (0.0004 + (405 * VAR("ramp")))))
vc136 = average(clipX(vtime('tran "/vo") (0.0004 + (405 * VAR("ramp"))) (0.0004 + (408 * VAR("ramp")))))
vc137 = average(clipX(vtime('tran "/vo") (0.0004 + (408 * VAR("ramp"))) (0.0004 + (411 * VAR("ramp")))))
vc138 = average(clipX(vtime('tran "/vo") (0.0004 + (411 * VAR("ramp"))) (0.0004 + (414 * VAR("ramp")))))
vc139 = average(clipX(vtime('tran "/vo") (0.0004 + (414 * VAR("ramp"))) (0.0004 + (417 * VAR("ramp")))))
vc140 = average(clipX(vtime('tran "/vo") (0.0004 + (417 * VAR("ramp"))) (0.0004 + (420 * VAR("ramp")))))
vc141 = average(clipX(vtime('tran "/vo") (0.0004 + (420 * VAR("ramp"))) (0.0004 + (423 * VAR("ramp")))))
vc142 = average(clipX(vtime('tran "/vo") (0.0004 + (423 * VAR("ramp"))) (0.0004 + (426 * VAR("ramp")))))
vc143 = average(clipX(vtime('tran "/vo") (0.0004 + (426 * VAR("ramp"))) (0.0004 + (429 * VAR("ramp")))))
vc144 = average(clipX(vtime('tran "/vo") (0.0004 + (429 * VAR("ramp"))) (0.0004 + (432 * VAR("ramp")))))
vc145 = average(clipX(vtime('tran "/vo") (0.0004 + (432 * VAR("ramp"))) (0.0004 + (435 * VAR("ramp")))))
vc146 = average(clipX(vtime('tran "/vo") (0.0004 + (435 * VAR("ramp"))) (0.0004 + (438 * VAR("ramp")))))
vc147 = average(clipX(vtime('tran "/vo") (0.0004 + (438 * VAR("ramp"))) (0.0004 + (441 * VAR("ramp")))))
vc148 = average(clipX(vtime('tran "/vo") (0.0004 + (441 * VAR("ramp"))) (0.0004 + (444 * VAR("ramp")))))
vc149 = average(clipX(vtime('tran "/vo") (0.0004 + (444 * VAR("ramp"))) (0.0004 + (447 * VAR("ramp")))))
vc150 = average(clipX(vtime('tran "/vo") (0.0004 + (447 * VAR("ramp"))) (0.0004 + (450 * VAR("ramp")))))
vc151 = average(clipX(vtime('tran "/vo") (0.0004 + (450 * VAR("ramp"))) (0.0004 + (453 * VAR("ramp")))))
vc152 = average(clipX(vtime('tran "/vo") (0.0004 + (453 * VAR("ramp"))) (0.0004 + (456 * VAR("ramp")))))
vc153 = average(clipX(vtime('tran "/vo") (0.0004 + (456 * VAR("ramp"))) (0.0004 + (459 * VAR("ramp")))))
vc154 = average(clipX(vtime('tran "/vo") (0.0004 + (459 * VAR("ramp"))) (0.0004 + (462 * VAR("ramp")))))
vc155 = average(clipX(vtime('tran "/vo") (0.0004 + (462 * VAR("ramp"))) (0.0004 + (465 * VAR("ramp")))))
vc156 = average(clipX(vtime('tran "/vo") (0.0004 + (465 * VAR("ramp"))) (0.0004 + (468 * VAR("ramp")))))
vc157 = average(clipX(vtime('tran "/vo") (0.0004 + (468 * VAR("ramp"))) (0.0004 + (471 * VAR("ramp")))))
vc158 = average(clipX(vtime('tran "/vo") (0.0004 + (471 * VAR("ramp"))) (0.0004 + (474 * VAR("ramp")))))
vc159 = average(clipX(vtime('tran "/vo") (0.0004 + (474 * VAR("ramp"))) (0.0004 + (477 * VAR("ramp")))))
vc160 = average(clipX(vtime('tran "/vo") (0.0004 + (477 * VAR("ramp"))) (0.0004 + (480 * VAR("ramp")))))
vc161 = average(clipX(vtime('tran "/vo") (0.0004 + (480 * VAR("ramp"))) (0.0004 + (483 * VAR("ramp")))))
vc162 = average(clipX(vtime('tran "/vo") (0.0004 + (483 * VAR("ramp"))) (0.0004 + (486 * VAR("ramp")))))
vc163 = average(clipX(vtime('tran "/vo") (0.0004 + (486 * VAR("ramp"))) (0.0004 + (489 * VAR("ramp")))))
vc164 = average(clipX(vtime('tran "/vo") (0.0004 + (489 * VAR("ramp"))) (0.0004 + (492 * VAR("ramp")))))
vc165 = average(clipX(vtime('tran "/vo") (0.0004 + (492 * VAR("ramp"))) (0.0004 + (495 * VAR("ramp")))))
vc166 = average(clipX(vtime('tran "/vo") (0.0004 + (495 * VAR("ramp"))) (0.0004 + (498 * VAR("ramp")))))
vc167 = average(clipX(vtime('tran "/vo") (0.0004 + (498 * VAR("ramp"))) (0.0004 + (501 * VAR("ramp")))))
vc168 = average(clipX(vtime('tran "/vo") (0.0004 + (501 * VAR("ramp"))) (0.0004 + (504 * VAR("ramp")))))
vc169 = average(clipX(vtime('tran "/vo") (0.0004 + (504 * VAR("ramp"))) (0.0004 + (507 * VAR("ramp")))))
vc170 = average(clipX(vtime('tran "/vo") (0.0004 + (507 * VAR("ramp"))) (0.0004 + (510 * VAR("ramp")))))
vc171 = average(clipX(vtime('tran "/vo") (0.0004 + (510 * VAR("ramp"))) (0.0004 + (513 * VAR("ramp")))))
vc172 = average(clipX(vtime('tran "/vo") (0.0004 + (513 * VAR("ramp"))) (0.0004 + (516 * VAR("ramp")))))
vc173 = average(clipX(vtime('tran "/vo") (0.0004 + (516 * VAR("ramp"))) (0.0004 + (519 * VAR("ramp")))))
vc174 = average(clipX(vtime('tran "/vo") (0.0004 + (519 * VAR("ramp"))) (0.0004 + (522 * VAR("ramp")))))
vc175 = average(clipX(vtime('tran "/vo") (0.0004 + (522 * VAR("ramp"))) (0.0004 + (525 * VAR("ramp")))))
vc176 = average(clipX(vtime('tran "/vo") (0.0004 + (525 * VAR("ramp"))) (0.0004 + (528 * VAR("ramp")))))
vc177 = average(clipX(vtime('tran "/vo") (0.0004 + (528 * VAR("ramp"))) (0.0004 + (531 * VAR("ramp")))))
vc178 = average(clipX(vtime('tran "/vo") (0.0004 + (531 * VAR("ramp"))) (0.0004 + (534 * VAR("ramp")))))
vc179 = average(clipX(vtime('tran "/vo") (0.0004 + (534 * VAR("ramp"))) (0.0004 + (537 * VAR("ramp")))))
vc180 = average(clipX(vtime('tran "/vo") (0.0004 + (537 * VAR("ramp"))) (0.0004 + (540 * VAR("ramp")))))
vc181 = average(clipX(vtime('tran "/vo") (0.0004 + (540 * VAR("ramp"))) (0.0004 + (543 * VAR("ramp")))))
vc182 = average(clipX(vtime('tran "/vo") (0.0004 + (543 * VAR("ramp"))) (0.0004 + (546 * VAR("ramp")))))
vc183 = average(clipX(vtime('tran "/vo") (0.0004 + (546 * VAR("ramp"))) (0.0004 + (549 * VAR("ramp")))))
vc184 = average(clipX(vtime('tran "/vo") (0.0004 + (549 * VAR("ramp"))) (0.0004 + (552 * VAR("ramp")))))
vc185 = average(clipX(vtime('tran "/vo") (0.0004 + (552 * VAR("ramp"))) (0.0004 + (555 * VAR("ramp")))))
vc186 = average(clipX(vtime('tran "/vo") (0.0004 + (555 * VAR("ramp"))) (0.0004 + (558 * VAR("ramp")))))
vc187 = average(clipX(vtime('tran "/vo") (0.0004 + (558 * VAR("ramp"))) (0.0004 + (561 * VAR("ramp")))))
vc188 = average(clipX(vtime('tran "/vo") (0.0004 + (561 * VAR("ramp"))) (0.0004 + (564 * VAR("ramp")))))
vc189 = average(clipX(vtime('tran "/vo") (0.0004 + (564 * VAR("ramp"))) (0.0004 + (567 * VAR("ramp")))))
vc190 = average(clipX(vtime('tran "/vo") (0.0004 + (567 * VAR("ramp"))) (0.0004 + (570 * VAR("ramp")))))
vc191 = average(clipX(vtime('tran "/vo") (0.0004 + (570 * VAR("ramp"))) (0.0004 + (573 * VAR("ramp")))))
vc192 = average(clipX(vtime('tran "/vo") (0.0004 + (573 * VAR("ramp"))) (0.0004 + (576 * VAR("ramp")))))
vc193 = average(clipX(vtime('tran "/vo") (0.0004 + (576 * VAR("ramp"))) (0.0004 + (579 * VAR("ramp")))))
vc194 = average(clipX(vtime('tran "/vo") (0.0004 + (579 * VAR("ramp"))) (0.0004 + (582 * VAR("ramp")))))
vc195 = average(clipX(vtime('tran "/vo") (0.0004 + (582 * VAR("ramp"))) (0.0004 + (585 * VAR("ramp")))))
vc196 = average(clipX(vtime('tran "/vo") (0.0004 + (585 * VAR("ramp"))) (0.0004 + (588 * VAR("ramp")))))
vc197 = average(clipX(vtime('tran "/vo") (0.0004 + (588 * VAR("ramp"))) (0.0004 + (591 * VAR("ramp")))))
vc198 = average(clipX(vtime('tran "/vo") (0.0004 + (591 * VAR("ramp"))) (0.0004 + (594 * VAR("ramp")))))
vc199 = average(clipX(vtime('tran "/vo") (0.0004 + (594 * VAR("ramp"))) (0.0004 + (597 * VAR("ramp")))))
vc200 = average(clipX(vtime('tran "/vo") (0.0004 + (597 * VAR("ramp"))) (0.0004 + (600 * VAR("ramp")))))
vc201 = average(clipX(vtime('tran "/vo") (0.0004 + (600 * VAR("ramp"))) (0.0004 + (603 * VAR("ramp")))))
vc202 = average(clipX(vtime('tran "/vo") (0.0004 + (603 * VAR("ramp"))) (0.0004 + (606 * VAR("ramp")))))
vc203 = average(clipX(vtime('tran "/vo") (0.0004 + (606 * VAR("ramp"))) (0.0004 + (609 * VAR("ramp")))))
vc204 = average(clipX(vtime('tran "/vo") (0.0004 + (609 * VAR("ramp"))) (0.0004 + (612 * VAR("ramp")))))
vc205 = average(clipX(vtime('tran "/vo") (0.0004 + (612 * VAR("ramp"))) (0.0004 + (615 * VAR("ramp")))))
vc206 = average(clipX(vtime('tran "/vo") (0.0004 + (615 * VAR("ramp"))) (0.0004 + (618 * VAR("ramp")))))
vc207 = average(clipX(vtime('tran "/vo") (0.0004 + (618 * VAR("ramp"))) (0.0004 + (621 * VAR("ramp")))))
vc208 = average(clipX(vtime('tran "/vo") (0.0004 + (621 * VAR("ramp"))) (0.0004 + (624 * VAR("ramp")))))
vc209 = average(clipX(vtime('tran "/vo") (0.0004 + (624 * VAR("ramp"))) (0.0004 + (627 * VAR("ramp")))))
vc210 = average(clipX(vtime('tran "/vo") (0.0004 + (627 * VAR("ramp"))) (0.0004 + (630 * VAR("ramp")))))
vc211 = average(clipX(vtime('tran "/vo") (0.0004 + (630 * VAR("ramp"))) (0.0004 + (633 * VAR("ramp")))))
vc212 = average(clipX(vtime('tran "/vo") (0.0004 + (633 * VAR("ramp"))) (0.0004 + (636 * VAR("ramp")))))
vc213 = average(clipX(vtime('tran "/vo") (0.0004 + (636 * VAR("ramp"))) (0.0004 + (639 * VAR("ramp")))))
vc214 = average(clipX(vtime('tran "/vo") (0.0004 + (639 * VAR("ramp"))) (0.0004 + (642 * VAR("ramp")))))
vc215 = average(clipX(vtime('tran "/vo") (0.0004 + (642 * VAR("ramp"))) (0.0004 + (645 * VAR("ramp")))))
vc216 = average(clipX(vtime('tran "/vo") (0.0004 + (645 * VAR("ramp"))) (0.0004 + (648 * VAR("ramp")))))
vc217 = average(clipX(vtime('tran "/vo") (0.0004 + (648 * VAR("ramp"))) (0.0004 + (651 * VAR("ramp")))))
vc218 = average(clipX(vtime('tran "/vo") (0.0004 + (651 * VAR("ramp"))) (0.0004 + (654 * VAR("ramp")))))
vc219 = average(clipX(vtime('tran "/vo") (0.0004 + (654 * VAR("ramp"))) (0.0004 + (657 * VAR("ramp")))))
vc220 = average(clipX(vtime('tran "/vo") (0.0004 + (657 * VAR("ramp"))) (0.0004 + (660 * VAR("ramp")))))
vc221 = average(clipX(vtime('tran "/vo") (0.0004 + (660 * VAR("ramp"))) (0.0004 + (663 * VAR("ramp")))))
vc222 = average(clipX(vtime('tran "/vo") (0.0004 + (663 * VAR("ramp"))) (0.0004 + (666 * VAR("ramp")))))
vc223 = average(clipX(vtime('tran "/vo") (0.0004 + (666 * VAR("ramp"))) (0.0004 + (669 * VAR("ramp")))))
vc224 = average(clipX(vtime('tran "/vo") (0.0004 + (669 * VAR("ramp"))) (0.0004 + (672 * VAR("ramp")))))
vc225 = average(clipX(vtime('tran "/vo") (0.0004 + (672 * VAR("ramp"))) (0.0004 + (675 * VAR("ramp")))))
vc226 = average(clipX(vtime('tran "/vo") (0.0004 + (675 * VAR("ramp"))) (0.0004 + (678 * VAR("ramp")))))
vc227 = average(clipX(vtime('tran "/vo") (0.0004 + (678 * VAR("ramp"))) (0.0004 + (681 * VAR("ramp")))))
vc228 = average(clipX(vtime('tran "/vo") (0.0004 + (681 * VAR("ramp"))) (0.0004 + (684 * VAR("ramp")))))
vc229 = average(clipX(vtime('tran "/vo") (0.0004 + (684 * VAR("ramp"))) (0.0004 + (687 * VAR("ramp")))))
vc230 = average(clipX(vtime('tran "/vo") (0.0004 + (687 * VAR("ramp"))) (0.0004 + (690 * VAR("ramp")))))
vc231 = average(clipX(vtime('tran "/vo") (0.0004 + (690 * VAR("ramp"))) (0.0004 + (693 * VAR("ramp")))))
vc232 = average(clipX(vtime('tran "/vo") (0.0004 + (693 * VAR("ramp"))) (0.0004 + (696 * VAR("ramp")))))
vc233 = average(clipX(vtime('tran "/vo") (0.0004 + (696 * VAR("ramp"))) (0.0004 + (699 * VAR("ramp")))))
vc234 = average(clipX(vtime('tran "/vo") (0.0004 + (699 * VAR("ramp"))) (0.0004 + (702 * VAR("ramp")))))
vc235 = average(clipX(vtime('tran "/vo") (0.0004 + (702 * VAR("ramp"))) (0.0004 + (705 * VAR("ramp")))))
vc236 = average(clipX(vtime('tran "/vo") (0.0004 + (705 * VAR("ramp"))) (0.0004 + (708 * VAR("ramp")))))
vc237 = average(clipX(vtime('tran "/vo") (0.0004 + (708 * VAR("ramp"))) (0.0004 + (711 * VAR("ramp")))))
vc238 = average(clipX(vtime('tran "/vo") (0.0004 + (711 * VAR("ramp"))) (0.0004 + (714 * VAR("ramp")))))
vc239 = average(clipX(vtime('tran "/vo") (0.0004 + (714 * VAR("ramp"))) (0.0004 + (717 * VAR("ramp")))))
vc240 = average(clipX(vtime('tran "/vo") (0.0004 + (717 * VAR("ramp"))) (0.0004 + (720 * VAR("ramp")))))
vc241 = average(clipX(vtime('tran "/vo") (0.0004 + (720 * VAR("ramp"))) (0.0004 + (723 * VAR("ramp")))))
vc242 = average(clipX(vtime('tran "/vo") (0.0004 + (723 * VAR("ramp"))) (0.0004 + (726 * VAR("ramp")))))
vc243 = average(clipX(vtime('tran "/vo") (0.0004 + (726 * VAR("ramp"))) (0.0004 + (729 * VAR("ramp")))))
vc244 = average(clipX(vtime('tran "/vo") (0.0004 + (729 * VAR("ramp"))) (0.0004 + (732 * VAR("ramp")))))
vc245 = average(clipX(vtime('tran "/vo") (0.0004 + (732 * VAR("ramp"))) (0.0004 + (735 * VAR("ramp")))))
vc246 = average(clipX(vtime('tran "/vo") (0.0004 + (735 * VAR("ramp"))) (0.0004 + (738 * VAR("ramp")))))
vc247 = average(clipX(vtime('tran "/vo") (0.0004 + (738 * VAR("ramp"))) (0.0004 + (741 * VAR("ramp")))))
vc248 = average(clipX(vtime('tran "/vo") (0.0004 + (741 * VAR("ramp"))) (0.0004 + (744 * VAR("ramp")))))
vc249 = average(clipX(vtime('tran "/vo") (0.0004 + (744 * VAR("ramp"))) (0.0004 + (747 * VAR("ramp")))))
vc250 = average(clipX(vtime('tran "/vo") (0.0004 + (747 * VAR("ramp"))) (0.0004 + (750 * VAR("ramp")))))
vc251 = average(clipX(vtime('tran "/vo") (0.0004 + (750 * VAR("ramp"))) (0.0004 + (753 * VAR("ramp")))))
vc252 = average(clipX(vtime('tran "/vo") (0.0004 + (753 * VAR("ramp"))) (0.0004 + (756 * VAR("ramp")))))
vc253 = average(clipX(vtime('tran "/vo") (0.0004 + (756 * VAR("ramp"))) (0.0004 + (759 * VAR("ramp")))))
vc254 = average(clipX(vtime('tran "/vo") (0.0004 + (759 * VAR("ramp"))) (0.0004 + (762 * VAR("ramp")))))
vc255 = average(clipX(vtime('tran "/vo") (0.0004 + (762 * VAR("ramp"))) (0.0004 + (765 * VAR("ramp")))))
vc256 = average(clipX(vtime('tran "/vo") (0.0004 + (765 * VAR("ramp"))) (0.0004 + (768 * VAR("ramp")))))
vc257 = average(clipX(vtime('tran "/vo") (0.0004 + (768 * VAR("ramp"))) (0.0004 + (771 * VAR("ramp")))))
vc258 = average(clipX(vtime('tran "/vo") (0.0004 + (771 * VAR("ramp"))) (0.0004 + (774 * VAR("ramp")))))
vc259 = average(clipX(vtime('tran "/vo") (0.0004 + (774 * VAR("ramp"))) (0.0004 + (777 * VAR("ramp")))))
vc260 = average(clipX(vtime('tran "/vo") (0.0004 + (777 * VAR("ramp"))) (0.0004 + (780 * VAR("ramp")))))
vc261 = average(clipX(vtime('tran "/vo") (0.0004 + (780 * VAR("ramp"))) (0.0004 + (783 * VAR("ramp")))))
vc262 = average(clipX(vtime('tran "/vo") (0.0004 + (783 * VAR("ramp"))) (0.0004 + (786 * VAR("ramp")))))
vc263 = average(clipX(vtime('tran "/vo") (0.0004 + (786 * VAR("ramp"))) (0.0004 + (789 * VAR("ramp")))))
vc264 = average(clipX(vtime('tran "/vo") (0.0004 + (789 * VAR("ramp"))) (0.0004 + (792 * VAR("ramp")))))
vc265 = average(clipX(vtime('tran "/vo") (0.0004 + (792 * VAR("ramp"))) (0.0004 + (795 * VAR("ramp")))))
vc266 = average(clipX(vtime('tran "/vo") (0.0004 + (795 * VAR("ramp"))) (0.0004 + (798 * VAR("ramp")))))
vc267 = average(clipX(vtime('tran "/vo") (0.0004 + (798 * VAR("ramp"))) (0.0004 + (801 * VAR("ramp")))))
vc268 = average(clipX(vtime('tran "/vo") (0.0004 + (801 * VAR("ramp"))) (0.0004 + (804 * VAR("ramp")))))
vc269 = average(clipX(vtime('tran "/vo") (0.0004 + (804 * VAR("ramp"))) (0.0004 + (807 * VAR("ramp")))))
vc270 = average(clipX(vtime('tran "/vo") (0.0004 + (807 * VAR("ramp"))) (0.0004 + (810 * VAR("ramp")))))
vc271 = average(clipX(vtime('tran "/vo") (0.0004 + (810 * VAR("ramp"))) (0.0004 + (813 * VAR("ramp")))))
vc272 = average(clipX(vtime('tran "/vo") (0.0004 + (813 * VAR("ramp"))) (0.0004 + (816 * VAR("ramp")))))
vc273 = average(clipX(vtime('tran "/vo") (0.0004 + (816 * VAR("ramp"))) (0.0004 + (819 * VAR("ramp")))))
vc274 = average(clipX(vtime('tran "/vo") (0.0004 + (819 * VAR("ramp"))) (0.0004 + (822 * VAR("ramp")))))
vc275 = average(clipX(vtime('tran "/vo") (0.0004 + (822 * VAR("ramp"))) (0.0004 + (825 * VAR("ramp")))))
vc276 = average(clipX(vtime('tran "/vo") (0.0004 + (825 * VAR("ramp"))) (0.0004 + (828 * VAR("ramp")))))
vc277 = average(clipX(vtime('tran "/vo") (0.0004 + (828 * VAR("ramp"))) (0.0004 + (831 * VAR("ramp")))))
vc278 = average(clipX(vtime('tran "/vo") (0.0004 + (831 * VAR("ramp"))) (0.0004 + (834 * VAR("ramp")))))
vc279 = average(clipX(vtime('tran "/vo") (0.0004 + (834 * VAR("ramp"))) (0.0004 + (837 * VAR("ramp")))))
vc280 = average(clipX(vtime('tran "/vo") (0.0004 + (837 * VAR("ramp"))) (0.0004 + (840 * VAR("ramp")))))
vc281 = average(clipX(vtime('tran "/vo") (0.0004 + (840 * VAR("ramp"))) (0.0004 + (843 * VAR("ramp")))))
vc282 = average(clipX(vtime('tran "/vo") (0.0004 + (843 * VAR("ramp"))) (0.0004 + (846 * VAR("ramp")))))
vc283 = average(clipX(vtime('tran "/vo") (0.0004 + (846 * VAR("ramp"))) (0.0004 + (849 * VAR("ramp")))))
vc284 = average(clipX(vtime('tran "/vo") (0.0004 + (849 * VAR("ramp"))) (0.0004 + (852 * VAR("ramp")))))
vc285 = average(clipX(vtime('tran "/vo") (0.0004 + (852 * VAR("ramp"))) (0.0004 + (855 * VAR("ramp")))))
vc286 = average(clipX(vtime('tran "/vo") (0.0004 + (855 * VAR("ramp"))) (0.0004 + (858 * VAR("ramp")))))
vc287 = average(clipX(vtime('tran "/vo") (0.0004 + (858 * VAR("ramp"))) (0.0004 + (861 * VAR("ramp")))))
vc288 = average(clipX(vtime('tran "/vo") (0.0004 + (861 * VAR("ramp"))) (0.0004 + (864 * VAR("ramp")))))
vc289 = average(clipX(vtime('tran "/vo") (0.0004 + (864 * VAR("ramp"))) (0.0004 + (867 * VAR("ramp")))))
vc290 = average(clipX(vtime('tran "/vo") (0.0004 + (867 * VAR("ramp"))) (0.0004 + (870 * VAR("ramp")))))
vc291 = average(clipX(vtime('tran "/vo") (0.0004 + (870 * VAR("ramp"))) (0.0004 + (873 * VAR("ramp")))))
vc292 = average(clipX(vtime('tran "/vo") (0.0004 + (873 * VAR("ramp"))) (0.0004 + (876 * VAR("ramp")))))
vc293 = average(clipX(vtime('tran "/vo") (0.0004 + (876 * VAR("ramp"))) (0.0004 + (879 * VAR("ramp")))))
vc294 = average(clipX(vtime('tran "/vo") (0.0004 + (879 * VAR("ramp"))) (0.0004 + (882 * VAR("ramp")))))
vc295 = average(clipX(vtime('tran "/vo") (0.0004 + (882 * VAR("ramp"))) (0.0004 + (885 * VAR("ramp")))))
vc296 = average(clipX(vtime('tran "/vo") (0.0004 + (885 * VAR("ramp"))) (0.0004 + (888 * VAR("ramp")))))
vc297 = average(clipX(vtime('tran "/vo") (0.0004 + (888 * VAR("ramp"))) (0.0004 + (891 * VAR("ramp")))))
vc298 = average(clipX(vtime('tran "/vo") (0.0004 + (891 * VAR("ramp"))) (0.0004 + (894 * VAR("ramp")))))
vc299 = average(clipX(vtime('tran "/vo") (0.0004 + (894 * VAR("ramp"))) (0.0004 + (897 * VAR("ramp")))))
vc300 = average(clipX(vtime('tran "/vo") (0.0004 + (897 * VAR("ramp"))) (0.0004 + (900 * VAR("ramp")))))

ea1 = average(clipX(vtime('tran "/ea") (0.0004 + (0 * VAR("ramp"))) (0.0004 + (3 * VAR("ramp")))))
ea2 = average(clipX(vtime('tran "/ea") (0.0004 + (3 * VAR("ramp"))) (0.0004 + (6 * VAR("ramp")))))
ea3 = average(clipX(vtime('tran "/ea") (0.0004 + (6 * VAR("ramp"))) (0.0004 + (9 * VAR("ramp")))))
ea4 = average(clipX(vtime('tran "/ea") (0.0004 + (9 * VAR("ramp"))) (0.0004 + (12 * VAR("ramp")))))
ea5 = average(clipX(vtime('tran "/ea") (0.0004 + (12 * VAR("ramp"))) (0.0004 + (15 * VAR("ramp")))))
ea6 = average(clipX(vtime('tran "/ea") (0.0004 + (15 * VAR("ramp"))) (0.0004 + (18 * VAR("ramp")))))
ea7 = average(clipX(vtime('tran "/ea") (0.0004 + (18 * VAR("ramp"))) (0.0004 + (21 * VAR("ramp")))))
ea8 = average(clipX(vtime('tran "/ea") (0.0004 + (21 * VAR("ramp"))) (0.0004 + (24 * VAR("ramp")))))
ea9 = average(clipX(vtime('tran "/ea") (0.0004 + (24 * VAR("ramp"))) (0.0004 + (27 * VAR("ramp")))))
ea10 = average(clipX(vtime('tran "/ea") (0.0004 + (27 * VAR("ramp"))) (0.0004 + (30 * VAR("ramp")))))
ea11 = average(clipX(vtime('tran "/ea") (0.0004 + (30 * VAR("ramp"))) (0.0004 + (33 * VAR("ramp")))))
ea12 = average(clipX(vtime('tran "/ea") (0.0004 + (33 * VAR("ramp"))) (0.0004 + (36 * VAR("ramp")))))
ea13 = average(clipX(vtime('tran "/ea") (0.0004 + (36 * VAR("ramp"))) (0.0004 + (39 * VAR("ramp")))))
ea14 = average(clipX(vtime('tran "/ea") (0.0004 + (39 * VAR("ramp"))) (0.0004 + (42 * VAR("ramp")))))
ea15 = average(clipX(vtime('tran "/ea") (0.0004 + (42 * VAR("ramp"))) (0.0004 + (45 * VAR("ramp")))))
ea16 = average(clipX(vtime('tran "/ea") (0.0004 + (45 * VAR("ramp"))) (0.0004 + (48 * VAR("ramp")))))
ea17 = average(clipX(vtime('tran "/ea") (0.0004 + (48 * VAR("ramp"))) (0.0004 + (51 * VAR("ramp")))))
ea18 = average(clipX(vtime('tran "/ea") (0.0004 + (51 * VAR("ramp"))) (0.0004 + (54 * VAR("ramp")))))
ea19 = average(clipX(vtime('tran "/ea") (0.0004 + (54 * VAR("ramp"))) (0.0004 + (57 * VAR("ramp")))))
ea20 = average(clipX(vtime('tran "/ea") (0.0004 + (57 * VAR("ramp"))) (0.0004 + (60 * VAR("ramp")))))
ea21 = average(clipX(vtime('tran "/ea") (0.0004 + (60 * VAR("ramp"))) (0.0004 + (63 * VAR("ramp")))))
ea22 = average(clipX(vtime('tran "/ea") (0.0004 + (63 * VAR("ramp"))) (0.0004 + (66 * VAR("ramp")))))
ea23 = average(clipX(vtime('tran "/ea") (0.0004 + (66 * VAR("ramp"))) (0.0004 + (69 * VAR("ramp")))))
ea24 = average(clipX(vtime('tran "/ea") (0.0004 + (69 * VAR("ramp"))) (0.0004 + (72 * VAR("ramp")))))
ea25 = average(clipX(vtime('tran "/ea") (0.0004 + (72 * VAR("ramp"))) (0.0004 + (75 * VAR("ramp")))))
ea26 = average(clipX(vtime('tran "/ea") (0.0004 + (75 * VAR("ramp"))) (0.0004 + (78 * VAR("ramp")))))
ea27 = average(clipX(vtime('tran "/ea") (0.0004 + (78 * VAR("ramp"))) (0.0004 + (81 * VAR("ramp")))))
ea28 = average(clipX(vtime('tran "/ea") (0.0004 + (81 * VAR("ramp"))) (0.0004 + (84 * VAR("ramp")))))
ea29 = average(clipX(vtime('tran "/ea") (0.0004 + (84 * VAR("ramp"))) (0.0004 + (87 * VAR("ramp")))))
ea30 = average(clipX(vtime('tran "/ea") (0.0004 + (87 * VAR("ramp"))) (0.0004 + (90 * VAR("ramp")))))
ea31 = average(clipX(vtime('tran "/ea") (0.0004 + (90 * VAR("ramp"))) (0.0004 + (93 * VAR("ramp")))))
ea32 = average(clipX(vtime('tran "/ea") (0.0004 + (93 * VAR("ramp"))) (0.0004 + (96 * VAR("ramp")))))
ea33 = average(clipX(vtime('tran "/ea") (0.0004 + (96 * VAR("ramp"))) (0.0004 + (99 * VAR("ramp")))))
ea34 = average(clipX(vtime('tran "/ea") (0.0004 + (99 * VAR("ramp"))) (0.0004 + (102 * VAR("ramp")))))
ea35 = average(clipX(vtime('tran "/ea") (0.0004 + (102 * VAR("ramp"))) (0.0004 + (105 * VAR("ramp")))))
ea36 = average(clipX(vtime('tran "/ea") (0.0004 + (105 * VAR("ramp"))) (0.0004 + (108 * VAR("ramp")))))
ea37 = average(clipX(vtime('tran "/ea") (0.0004 + (108 * VAR("ramp"))) (0.0004 + (111 * VAR("ramp")))))
ea38 = average(clipX(vtime('tran "/ea") (0.0004 + (111 * VAR("ramp"))) (0.0004 + (114 * VAR("ramp")))))
ea39 = average(clipX(vtime('tran "/ea") (0.0004 + (114 * VAR("ramp"))) (0.0004 + (117 * VAR("ramp")))))
ea40 = average(clipX(vtime('tran "/ea") (0.0004 + (117 * VAR("ramp"))) (0.0004 + (120 * VAR("ramp")))))
ea41 = average(clipX(vtime('tran "/ea") (0.0004 + (120 * VAR("ramp"))) (0.0004 + (123 * VAR("ramp")))))
ea42 = average(clipX(vtime('tran "/ea") (0.0004 + (123 * VAR("ramp"))) (0.0004 + (126 * VAR("ramp")))))
ea43 = average(clipX(vtime('tran "/ea") (0.0004 + (126 * VAR("ramp"))) (0.0004 + (129 * VAR("ramp")))))
ea44 = average(clipX(vtime('tran "/ea") (0.0004 + (129 * VAR("ramp"))) (0.0004 + (132 * VAR("ramp")))))
ea45 = average(clipX(vtime('tran "/ea") (0.0004 + (132 * VAR("ramp"))) (0.0004 + (135 * VAR("ramp")))))
ea46 = average(clipX(vtime('tran "/ea") (0.0004 + (135 * VAR("ramp"))) (0.0004 + (138 * VAR("ramp")))))
ea47 = average(clipX(vtime('tran "/ea") (0.0004 + (138 * VAR("ramp"))) (0.0004 + (141 * VAR("ramp")))))
ea48 = average(clipX(vtime('tran "/ea") (0.0004 + (141 * VAR("ramp"))) (0.0004 + (144 * VAR("ramp")))))
ea49 = average(clipX(vtime('tran "/ea") (0.0004 + (144 * VAR("ramp"))) (0.0004 + (147 * VAR("ramp")))))
ea50 = average(clipX(vtime('tran "/ea") (0.0004 + (147 * VAR("ramp"))) (0.0004 + (150 * VAR("ramp")))))
ea51 = average(clipX(vtime('tran "/ea") (0.0004 + (150 * VAR("ramp"))) (0.0004 + (153 * VAR("ramp")))))
ea52 = average(clipX(vtime('tran "/ea") (0.0004 + (153 * VAR("ramp"))) (0.0004 + (156 * VAR("ramp")))))
ea53 = average(clipX(vtime('tran "/ea") (0.0004 + (156 * VAR("ramp"))) (0.0004 + (159 * VAR("ramp")))))
ea54 = average(clipX(vtime('tran "/ea") (0.0004 + (159 * VAR("ramp"))) (0.0004 + (162 * VAR("ramp")))))
ea55 = average(clipX(vtime('tran "/ea") (0.0004 + (162 * VAR("ramp"))) (0.0004 + (165 * VAR("ramp")))))
ea56 = average(clipX(vtime('tran "/ea") (0.0004 + (165 * VAR("ramp"))) (0.0004 + (168 * VAR("ramp")))))
ea57 = average(clipX(vtime('tran "/ea") (0.0004 + (168 * VAR("ramp"))) (0.0004 + (171 * VAR("ramp")))))
ea58 = average(clipX(vtime('tran "/ea") (0.0004 + (171 * VAR("ramp"))) (0.0004 + (174 * VAR("ramp")))))
ea59 = average(clipX(vtime('tran "/ea") (0.0004 + (174 * VAR("ramp"))) (0.0004 + (177 * VAR("ramp")))))
ea60 = average(clipX(vtime('tran "/ea") (0.0004 + (177 * VAR("ramp"))) (0.0004 + (180 * VAR("ramp")))))
ea61 = average(clipX(vtime('tran "/ea") (0.0004 + (180 * VAR("ramp"))) (0.0004 + (183 * VAR("ramp")))))
ea62 = average(clipX(vtime('tran "/ea") (0.0004 + (183 * VAR("ramp"))) (0.0004 + (186 * VAR("ramp")))))
ea63 = average(clipX(vtime('tran "/ea") (0.0004 + (186 * VAR("ramp"))) (0.0004 + (189 * VAR("ramp")))))
ea64 = average(clipX(vtime('tran "/ea") (0.0004 + (189 * VAR("ramp"))) (0.0004 + (192 * VAR("ramp")))))
ea65 = average(clipX(vtime('tran "/ea") (0.0004 + (192 * VAR("ramp"))) (0.0004 + (195 * VAR("ramp")))))
ea66 = average(clipX(vtime('tran "/ea") (0.0004 + (195 * VAR("ramp"))) (0.0004 + (198 * VAR("ramp")))))
ea67 = average(clipX(vtime('tran "/ea") (0.0004 + (198 * VAR("ramp"))) (0.0004 + (201 * VAR("ramp")))))
ea68 = average(clipX(vtime('tran "/ea") (0.0004 + (201 * VAR("ramp"))) (0.0004 + (204 * VAR("ramp")))))
ea69 = average(clipX(vtime('tran "/ea") (0.0004 + (204 * VAR("ramp"))) (0.0004 + (207 * VAR("ramp")))))
ea70 = average(clipX(vtime('tran "/ea") (0.0004 + (207 * VAR("ramp"))) (0.0004 + (210 * VAR("ramp")))))
ea71 = average(clipX(vtime('tran "/ea") (0.0004 + (210 * VAR("ramp"))) (0.0004 + (213 * VAR("ramp")))))
ea72 = average(clipX(vtime('tran "/ea") (0.0004 + (213 * VAR("ramp"))) (0.0004 + (216 * VAR("ramp")))))
ea73 = average(clipX(vtime('tran "/ea") (0.0004 + (216 * VAR("ramp"))) (0.0004 + (219 * VAR("ramp")))))
ea74 = average(clipX(vtime('tran "/ea") (0.0004 + (219 * VAR("ramp"))) (0.0004 + (222 * VAR("ramp")))))
ea75 = average(clipX(vtime('tran "/ea") (0.0004 + (222 * VAR("ramp"))) (0.0004 + (225 * VAR("ramp")))))
ea76 = average(clipX(vtime('tran "/ea") (0.0004 + (225 * VAR("ramp"))) (0.0004 + (228 * VAR("ramp")))))
ea77 = average(clipX(vtime('tran "/ea") (0.0004 + (228 * VAR("ramp"))) (0.0004 + (231 * VAR("ramp")))))
ea78 = average(clipX(vtime('tran "/ea") (0.0004 + (231 * VAR("ramp"))) (0.0004 + (234 * VAR("ramp")))))
ea79 = average(clipX(vtime('tran "/ea") (0.0004 + (234 * VAR("ramp"))) (0.0004 + (237 * VAR("ramp")))))
ea80 = average(clipX(vtime('tran "/ea") (0.0004 + (237 * VAR("ramp"))) (0.0004 + (240 * VAR("ramp")))))
ea81 = average(clipX(vtime('tran "/ea") (0.0004 + (240 * VAR("ramp"))) (0.0004 + (243 * VAR("ramp")))))
ea82 = average(clipX(vtime('tran "/ea") (0.0004 + (243 * VAR("ramp"))) (0.0004 + (246 * VAR("ramp")))))
ea83 = average(clipX(vtime('tran "/ea") (0.0004 + (246 * VAR("ramp"))) (0.0004 + (249 * VAR("ramp")))))
ea84 = average(clipX(vtime('tran "/ea") (0.0004 + (249 * VAR("ramp"))) (0.0004 + (252 * VAR("ramp")))))
ea85 = average(clipX(vtime('tran "/ea") (0.0004 + (252 * VAR("ramp"))) (0.0004 + (255 * VAR("ramp")))))
ea86 = average(clipX(vtime('tran "/ea") (0.0004 + (255 * VAR("ramp"))) (0.0004 + (258 * VAR("ramp")))))
ea87 = average(clipX(vtime('tran "/ea") (0.0004 + (258 * VAR("ramp"))) (0.0004 + (261 * VAR("ramp")))))
ea88 = average(clipX(vtime('tran "/ea") (0.0004 + (261 * VAR("ramp"))) (0.0004 + (264 * VAR("ramp")))))
ea89 = average(clipX(vtime('tran "/ea") (0.0004 + (264 * VAR("ramp"))) (0.0004 + (267 * VAR("ramp")))))
ea90 = average(clipX(vtime('tran "/ea") (0.0004 + (267 * VAR("ramp"))) (0.0004 + (270 * VAR("ramp")))))
ea91 = average(clipX(vtime('tran "/ea") (0.0004 + (270 * VAR("ramp"))) (0.0004 + (273 * VAR("ramp")))))
ea92 = average(clipX(vtime('tran "/ea") (0.0004 + (273 * VAR("ramp"))) (0.0004 + (276 * VAR("ramp")))))
ea93 = average(clipX(vtime('tran "/ea") (0.0004 + (276 * VAR("ramp"))) (0.0004 + (279 * VAR("ramp")))))
ea94 = average(clipX(vtime('tran "/ea") (0.0004 + (279 * VAR("ramp"))) (0.0004 + (282 * VAR("ramp")))))
ea95 = average(clipX(vtime('tran "/ea") (0.0004 + (282 * VAR("ramp"))) (0.0004 + (285 * VAR("ramp")))))
ea96 = average(clipX(vtime('tran "/ea") (0.0004 + (285 * VAR("ramp"))) (0.0004 + (288 * VAR("ramp")))))
ea97 = average(clipX(vtime('tran "/ea") (0.0004 + (288 * VAR("ramp"))) (0.0004 + (291 * VAR("ramp")))))
ea98 = average(clipX(vtime('tran "/ea") (0.0004 + (291 * VAR("ramp"))) (0.0004 + (294 * VAR("ramp")))))
ea99 = average(clipX(vtime('tran "/ea") (0.0004 + (294 * VAR("ramp"))) (0.0004 + (297 * VAR("ramp")))))
ea100 = average(clipX(vtime('tran "/ea") (0.0004 + (297 * VAR("ramp"))) (0.0004 + (300 * VAR("ramp")))))
ea101 = average(clipX(vtime('tran "/ea") (0.0004 + (300 * VAR("ramp"))) (0.0004 + (303 * VAR("ramp")))))
ea102 = average(clipX(vtime('tran "/ea") (0.0004 + (303 * VAR("ramp"))) (0.0004 + (306 * VAR("ramp")))))
ea103 = average(clipX(vtime('tran "/ea") (0.0004 + (306 * VAR("ramp"))) (0.0004 + (309 * VAR("ramp")))))
ea104 = average(clipX(vtime('tran "/ea") (0.0004 + (309 * VAR("ramp"))) (0.0004 + (312 * VAR("ramp")))))
ea105 = average(clipX(vtime('tran "/ea") (0.0004 + (312 * VAR("ramp"))) (0.0004 + (315 * VAR("ramp")))))
ea106 = average(clipX(vtime('tran "/ea") (0.0004 + (315 * VAR("ramp"))) (0.0004 + (318 * VAR("ramp")))))
ea107 = average(clipX(vtime('tran "/ea") (0.0004 + (318 * VAR("ramp"))) (0.0004 + (321 * VAR("ramp")))))
ea108 = average(clipX(vtime('tran "/ea") (0.0004 + (321 * VAR("ramp"))) (0.0004 + (324 * VAR("ramp")))))
ea109 = average(clipX(vtime('tran "/ea") (0.0004 + (324 * VAR("ramp"))) (0.0004 + (327 * VAR("ramp")))))
ea110 = average(clipX(vtime('tran "/ea") (0.0004 + (327 * VAR("ramp"))) (0.0004 + (330 * VAR("ramp")))))
ea111 = average(clipX(vtime('tran "/ea") (0.0004 + (330 * VAR("ramp"))) (0.0004 + (333 * VAR("ramp")))))
ea112 = average(clipX(vtime('tran "/ea") (0.0004 + (333 * VAR("ramp"))) (0.0004 + (336 * VAR("ramp")))))
ea113 = average(clipX(vtime('tran "/ea") (0.0004 + (336 * VAR("ramp"))) (0.0004 + (339 * VAR("ramp")))))
ea114 = average(clipX(vtime('tran "/ea") (0.0004 + (339 * VAR("ramp"))) (0.0004 + (342 * VAR("ramp")))))
ea115 = average(clipX(vtime('tran "/ea") (0.0004 + (342 * VAR("ramp"))) (0.0004 + (345 * VAR("ramp")))))
ea116 = average(clipX(vtime('tran "/ea") (0.0004 + (345 * VAR("ramp"))) (0.0004 + (348 * VAR("ramp")))))
ea117 = average(clipX(vtime('tran "/ea") (0.0004 + (348 * VAR("ramp"))) (0.0004 + (351 * VAR("ramp")))))
ea118 = average(clipX(vtime('tran "/ea") (0.0004 + (351 * VAR("ramp"))) (0.0004 + (354 * VAR("ramp")))))
ea119 = average(clipX(vtime('tran "/ea") (0.0004 + (354 * VAR("ramp"))) (0.0004 + (357 * VAR("ramp")))))
ea120 = average(clipX(vtime('tran "/ea") (0.0004 + (357 * VAR("ramp"))) (0.0004 + (360 * VAR("ramp")))))
ea121 = average(clipX(vtime('tran "/ea") (0.0004 + (360 * VAR("ramp"))) (0.0004 + (363 * VAR("ramp")))))
ea122 = average(clipX(vtime('tran "/ea") (0.0004 + (363 * VAR("ramp"))) (0.0004 + (366 * VAR("ramp")))))
ea123 = average(clipX(vtime('tran "/ea") (0.0004 + (366 * VAR("ramp"))) (0.0004 + (369 * VAR("ramp")))))
ea124 = average(clipX(vtime('tran "/ea") (0.0004 + (369 * VAR("ramp"))) (0.0004 + (372 * VAR("ramp")))))
ea125 = average(clipX(vtime('tran "/ea") (0.0004 + (372 * VAR("ramp"))) (0.0004 + (375 * VAR("ramp")))))
ea126 = average(clipX(vtime('tran "/ea") (0.0004 + (375 * VAR("ramp"))) (0.0004 + (378 * VAR("ramp")))))
ea127 = average(clipX(vtime('tran "/ea") (0.0004 + (378 * VAR("ramp"))) (0.0004 + (381 * VAR("ramp")))))
ea128 = average(clipX(vtime('tran "/ea") (0.0004 + (381 * VAR("ramp"))) (0.0004 + (384 * VAR("ramp")))))
ea129 = average(clipX(vtime('tran "/ea") (0.0004 + (384 * VAR("ramp"))) (0.0004 + (387 * VAR("ramp")))))
ea130 = average(clipX(vtime('tran "/ea") (0.0004 + (387 * VAR("ramp"))) (0.0004 + (390 * VAR("ramp")))))
ea131 = average(clipX(vtime('tran "/ea") (0.0004 + (390 * VAR("ramp"))) (0.0004 + (393 * VAR("ramp")))))
ea132 = average(clipX(vtime('tran "/ea") (0.0004 + (393 * VAR("ramp"))) (0.0004 + (396 * VAR("ramp")))))
ea133 = average(clipX(vtime('tran "/ea") (0.0004 + (396 * VAR("ramp"))) (0.0004 + (399 * VAR("ramp")))))
ea134 = average(clipX(vtime('tran "/ea") (0.0004 + (399 * VAR("ramp"))) (0.0004 + (402 * VAR("ramp")))))
ea135 = average(clipX(vtime('tran "/ea") (0.0004 + (402 * VAR("ramp"))) (0.0004 + (405 * VAR("ramp")))))
ea136 = average(clipX(vtime('tran "/ea") (0.0004 + (405 * VAR("ramp"))) (0.0004 + (408 * VAR("ramp")))))
ea137 = average(clipX(vtime('tran "/ea") (0.0004 + (408 * VAR("ramp"))) (0.0004 + (411 * VAR("ramp")))))
ea138 = average(clipX(vtime('tran "/ea") (0.0004 + (411 * VAR("ramp"))) (0.0004 + (414 * VAR("ramp")))))
ea139 = average(clipX(vtime('tran "/ea") (0.0004 + (414 * VAR("ramp"))) (0.0004 + (417 * VAR("ramp")))))
ea140 = average(clipX(vtime('tran "/ea") (0.0004 + (417 * VAR("ramp"))) (0.0004 + (420 * VAR("ramp")))))
ea141 = average(clipX(vtime('tran "/ea") (0.0004 + (420 * VAR("ramp"))) (0.0004 + (423 * VAR("ramp")))))
ea142 = average(clipX(vtime('tran "/ea") (0.0004 + (423 * VAR("ramp"))) (0.0004 + (426 * VAR("ramp")))))
ea143 = average(clipX(vtime('tran "/ea") (0.0004 + (426 * VAR("ramp"))) (0.0004 + (429 * VAR("ramp")))))
ea144 = average(clipX(vtime('tran "/ea") (0.0004 + (429 * VAR("ramp"))) (0.0004 + (432 * VAR("ramp")))))
ea145 = average(clipX(vtime('tran "/ea") (0.0004 + (432 * VAR("ramp"))) (0.0004 + (435 * VAR("ramp")))))
ea146 = average(clipX(vtime('tran "/ea") (0.0004 + (435 * VAR("ramp"))) (0.0004 + (438 * VAR("ramp")))))
ea147 = average(clipX(vtime('tran "/ea") (0.0004 + (438 * VAR("ramp"))) (0.0004 + (441 * VAR("ramp")))))
ea148 = average(clipX(vtime('tran "/ea") (0.0004 + (441 * VAR("ramp"))) (0.0004 + (444 * VAR("ramp")))))
ea149 = average(clipX(vtime('tran "/ea") (0.0004 + (444 * VAR("ramp"))) (0.0004 + (447 * VAR("ramp")))))
ea150 = average(clipX(vtime('tran "/ea") (0.0004 + (447 * VAR("ramp"))) (0.0004 + (450 * VAR("ramp")))))
ea151 = average(clipX(vtime('tran "/ea") (0.0004 + (450 * VAR("ramp"))) (0.0004 + (453 * VAR("ramp")))))
ea152 = average(clipX(vtime('tran "/ea") (0.0004 + (453 * VAR("ramp"))) (0.0004 + (456 * VAR("ramp")))))
ea153 = average(clipX(vtime('tran "/ea") (0.0004 + (456 * VAR("ramp"))) (0.0004 + (459 * VAR("ramp")))))
ea154 = average(clipX(vtime('tran "/ea") (0.0004 + (459 * VAR("ramp"))) (0.0004 + (462 * VAR("ramp")))))
ea155 = average(clipX(vtime('tran "/ea") (0.0004 + (462 * VAR("ramp"))) (0.0004 + (465 * VAR("ramp")))))
ea156 = average(clipX(vtime('tran "/ea") (0.0004 + (465 * VAR("ramp"))) (0.0004 + (468 * VAR("ramp")))))
ea157 = average(clipX(vtime('tran "/ea") (0.0004 + (468 * VAR("ramp"))) (0.0004 + (471 * VAR("ramp")))))
ea158 = average(clipX(vtime('tran "/ea") (0.0004 + (471 * VAR("ramp"))) (0.0004 + (474 * VAR("ramp")))))
ea159 = average(clipX(vtime('tran "/ea") (0.0004 + (474 * VAR("ramp"))) (0.0004 + (477 * VAR("ramp")))))
ea160 = average(clipX(vtime('tran "/ea") (0.0004 + (477 * VAR("ramp"))) (0.0004 + (480 * VAR("ramp")))))
ea161 = average(clipX(vtime('tran "/ea") (0.0004 + (480 * VAR("ramp"))) (0.0004 + (483 * VAR("ramp")))))
ea162 = average(clipX(vtime('tran "/ea") (0.0004 + (483 * VAR("ramp"))) (0.0004 + (486 * VAR("ramp")))))
ea163 = average(clipX(vtime('tran "/ea") (0.0004 + (486 * VAR("ramp"))) (0.0004 + (489 * VAR("ramp")))))
ea164 = average(clipX(vtime('tran "/ea") (0.0004 + (489 * VAR("ramp"))) (0.0004 + (492 * VAR("ramp")))))
ea165 = average(clipX(vtime('tran "/ea") (0.0004 + (492 * VAR("ramp"))) (0.0004 + (495 * VAR("ramp")))))
ea166 = average(clipX(vtime('tran "/ea") (0.0004 + (495 * VAR("ramp"))) (0.0004 + (498 * VAR("ramp")))))
ea167 = average(clipX(vtime('tran "/ea") (0.0004 + (498 * VAR("ramp"))) (0.0004 + (501 * VAR("ramp")))))
ea168 = average(clipX(vtime('tran "/ea") (0.0004 + (501 * VAR("ramp"))) (0.0004 + (504 * VAR("ramp")))))
ea169 = average(clipX(vtime('tran "/ea") (0.0004 + (504 * VAR("ramp"))) (0.0004 + (507 * VAR("ramp")))))
ea170 = average(clipX(vtime('tran "/ea") (0.0004 + (507 * VAR("ramp"))) (0.0004 + (510 * VAR("ramp")))))
ea171 = average(clipX(vtime('tran "/ea") (0.0004 + (510 * VAR("ramp"))) (0.0004 + (513 * VAR("ramp")))))
ea172 = average(clipX(vtime('tran "/ea") (0.0004 + (513 * VAR("ramp"))) (0.0004 + (516 * VAR("ramp")))))
ea173 = average(clipX(vtime('tran "/ea") (0.0004 + (516 * VAR("ramp"))) (0.0004 + (519 * VAR("ramp")))))
ea174 = average(clipX(vtime('tran "/ea") (0.0004 + (519 * VAR("ramp"))) (0.0004 + (522 * VAR("ramp")))))
ea175 = average(clipX(vtime('tran "/ea") (0.0004 + (522 * VAR("ramp"))) (0.0004 + (525 * VAR("ramp")))))
ea176 = average(clipX(vtime('tran "/ea") (0.0004 + (525 * VAR("ramp"))) (0.0004 + (528 * VAR("ramp")))))
ea177 = average(clipX(vtime('tran "/ea") (0.0004 + (528 * VAR("ramp"))) (0.0004 + (531 * VAR("ramp")))))
ea178 = average(clipX(vtime('tran "/ea") (0.0004 + (531 * VAR("ramp"))) (0.0004 + (534 * VAR("ramp")))))
ea179 = average(clipX(vtime('tran "/ea") (0.0004 + (534 * VAR("ramp"))) (0.0004 + (537 * VAR("ramp")))))
ea180 = average(clipX(vtime('tran "/ea") (0.0004 + (537 * VAR("ramp"))) (0.0004 + (540 * VAR("ramp")))))
ea181 = average(clipX(vtime('tran "/ea") (0.0004 + (540 * VAR("ramp"))) (0.0004 + (543 * VAR("ramp")))))
ea182 = average(clipX(vtime('tran "/ea") (0.0004 + (543 * VAR("ramp"))) (0.0004 + (546 * VAR("ramp")))))
ea183 = average(clipX(vtime('tran "/ea") (0.0004 + (546 * VAR("ramp"))) (0.0004 + (549 * VAR("ramp")))))
ea184 = average(clipX(vtime('tran "/ea") (0.0004 + (549 * VAR("ramp"))) (0.0004 + (552 * VAR("ramp")))))
ea185 = average(clipX(vtime('tran "/ea") (0.0004 + (552 * VAR("ramp"))) (0.0004 + (555 * VAR("ramp")))))
ea186 = average(clipX(vtime('tran "/ea") (0.0004 + (555 * VAR("ramp"))) (0.0004 + (558 * VAR("ramp")))))
ea187 = average(clipX(vtime('tran "/ea") (0.0004 + (558 * VAR("ramp"))) (0.0004 + (561 * VAR("ramp")))))
ea188 = average(clipX(vtime('tran "/ea") (0.0004 + (561 * VAR("ramp"))) (0.0004 + (564 * VAR("ramp")))))
ea189 = average(clipX(vtime('tran "/ea") (0.0004 + (564 * VAR("ramp"))) (0.0004 + (567 * VAR("ramp")))))
ea190 = average(clipX(vtime('tran "/ea") (0.0004 + (567 * VAR("ramp"))) (0.0004 + (570 * VAR("ramp")))))
ea191 = average(clipX(vtime('tran "/ea") (0.0004 + (570 * VAR("ramp"))) (0.0004 + (573 * VAR("ramp")))))
ea192 = average(clipX(vtime('tran "/ea") (0.0004 + (573 * VAR("ramp"))) (0.0004 + (576 * VAR("ramp")))))
ea193 = average(clipX(vtime('tran "/ea") (0.0004 + (576 * VAR("ramp"))) (0.0004 + (579 * VAR("ramp")))))
ea194 = average(clipX(vtime('tran "/ea") (0.0004 + (579 * VAR("ramp"))) (0.0004 + (582 * VAR("ramp")))))
ea195 = average(clipX(vtime('tran "/ea") (0.0004 + (582 * VAR("ramp"))) (0.0004 + (585 * VAR("ramp")))))
ea196 = average(clipX(vtime('tran "/ea") (0.0004 + (585 * VAR("ramp"))) (0.0004 + (588 * VAR("ramp")))))
ea197 = average(clipX(vtime('tran "/ea") (0.0004 + (588 * VAR("ramp"))) (0.0004 + (591 * VAR("ramp")))))
ea198 = average(clipX(vtime('tran "/ea") (0.0004 + (591 * VAR("ramp"))) (0.0004 + (594 * VAR("ramp")))))
ea199 = average(clipX(vtime('tran "/ea") (0.0004 + (594 * VAR("ramp"))) (0.0004 + (597 * VAR("ramp")))))
ea200 = average(clipX(vtime('tran "/ea") (0.0004 + (597 * VAR("ramp"))) (0.0004 + (600 * VAR("ramp")))))
ea201 = average(clipX(vtime('tran "/ea") (0.0004 + (600 * VAR("ramp"))) (0.0004 + (603 * VAR("ramp")))))
ea202 = average(clipX(vtime('tran "/ea") (0.0004 + (603 * VAR("ramp"))) (0.0004 + (606 * VAR("ramp")))))
ea203 = average(clipX(vtime('tran "/ea") (0.0004 + (606 * VAR("ramp"))) (0.0004 + (609 * VAR("ramp")))))
ea204 = average(clipX(vtime('tran "/ea") (0.0004 + (609 * VAR("ramp"))) (0.0004 + (612 * VAR("ramp")))))
ea205 = average(clipX(vtime('tran "/ea") (0.0004 + (612 * VAR("ramp"))) (0.0004 + (615 * VAR("ramp")))))
ea206 = average(clipX(vtime('tran "/ea") (0.0004 + (615 * VAR("ramp"))) (0.0004 + (618 * VAR("ramp")))))
ea207 = average(clipX(vtime('tran "/ea") (0.0004 + (618 * VAR("ramp"))) (0.0004 + (621 * VAR("ramp")))))
ea208 = average(clipX(vtime('tran "/ea") (0.0004 + (621 * VAR("ramp"))) (0.0004 + (624 * VAR("ramp")))))
ea209 = average(clipX(vtime('tran "/ea") (0.0004 + (624 * VAR("ramp"))) (0.0004 + (627 * VAR("ramp")))))
ea210 = average(clipX(vtime('tran "/ea") (0.0004 + (627 * VAR("ramp"))) (0.0004 + (630 * VAR("ramp")))))
ea211 = average(clipX(vtime('tran "/ea") (0.0004 + (630 * VAR("ramp"))) (0.0004 + (633 * VAR("ramp")))))
ea212 = average(clipX(vtime('tran "/ea") (0.0004 + (633 * VAR("ramp"))) (0.0004 + (636 * VAR("ramp")))))
ea213 = average(clipX(vtime('tran "/ea") (0.0004 + (636 * VAR("ramp"))) (0.0004 + (639 * VAR("ramp")))))
ea214 = average(clipX(vtime('tran "/ea") (0.0004 + (639 * VAR("ramp"))) (0.0004 + (642 * VAR("ramp")))))
ea215 = average(clipX(vtime('tran "/ea") (0.0004 + (642 * VAR("ramp"))) (0.0004 + (645 * VAR("ramp")))))
ea216 = average(clipX(vtime('tran "/ea") (0.0004 + (645 * VAR("ramp"))) (0.0004 + (648 * VAR("ramp")))))
ea217 = average(clipX(vtime('tran "/ea") (0.0004 + (648 * VAR("ramp"))) (0.0004 + (651 * VAR("ramp")))))
ea218 = average(clipX(vtime('tran "/ea") (0.0004 + (651 * VAR("ramp"))) (0.0004 + (654 * VAR("ramp")))))
ea219 = average(clipX(vtime('tran "/ea") (0.0004 + (654 * VAR("ramp"))) (0.0004 + (657 * VAR("ramp")))))
ea220 = average(clipX(vtime('tran "/ea") (0.0004 + (657 * VAR("ramp"))) (0.0004 + (660 * VAR("ramp")))))
ea221 = average(clipX(vtime('tran "/ea") (0.0004 + (660 * VAR("ramp"))) (0.0004 + (663 * VAR("ramp")))))
ea222 = average(clipX(vtime('tran "/ea") (0.0004 + (663 * VAR("ramp"))) (0.0004 + (666 * VAR("ramp")))))
ea223 = average(clipX(vtime('tran "/ea") (0.0004 + (666 * VAR("ramp"))) (0.0004 + (669 * VAR("ramp")))))
ea224 = average(clipX(vtime('tran "/ea") (0.0004 + (669 * VAR("ramp"))) (0.0004 + (672 * VAR("ramp")))))
ea225 = average(clipX(vtime('tran "/ea") (0.0004 + (672 * VAR("ramp"))) (0.0004 + (675 * VAR("ramp")))))
ea226 = average(clipX(vtime('tran "/ea") (0.0004 + (675 * VAR("ramp"))) (0.0004 + (678 * VAR("ramp")))))
ea227 = average(clipX(vtime('tran "/ea") (0.0004 + (678 * VAR("ramp"))) (0.0004 + (681 * VAR("ramp")))))
ea228 = average(clipX(vtime('tran "/ea") (0.0004 + (681 * VAR("ramp"))) (0.0004 + (684 * VAR("ramp")))))
ea229 = average(clipX(vtime('tran "/ea") (0.0004 + (684 * VAR("ramp"))) (0.0004 + (687 * VAR("ramp")))))
ea230 = average(clipX(vtime('tran "/ea") (0.0004 + (687 * VAR("ramp"))) (0.0004 + (690 * VAR("ramp")))))
ea231 = average(clipX(vtime('tran "/ea") (0.0004 + (690 * VAR("ramp"))) (0.0004 + (693 * VAR("ramp")))))
ea232 = average(clipX(vtime('tran "/ea") (0.0004 + (693 * VAR("ramp"))) (0.0004 + (696 * VAR("ramp")))))
ea233 = average(clipX(vtime('tran "/ea") (0.0004 + (696 * VAR("ramp"))) (0.0004 + (699 * VAR("ramp")))))
ea234 = average(clipX(vtime('tran "/ea") (0.0004 + (699 * VAR("ramp"))) (0.0004 + (702 * VAR("ramp")))))
ea235 = average(clipX(vtime('tran "/ea") (0.0004 + (702 * VAR("ramp"))) (0.0004 + (705 * VAR("ramp")))))
ea236 = average(clipX(vtime('tran "/ea") (0.0004 + (705 * VAR("ramp"))) (0.0004 + (708 * VAR("ramp")))))
ea237 = average(clipX(vtime('tran "/ea") (0.0004 + (708 * VAR("ramp"))) (0.0004 + (711 * VAR("ramp")))))
ea238 = average(clipX(vtime('tran "/ea") (0.0004 + (711 * VAR("ramp"))) (0.0004 + (714 * VAR("ramp")))))
ea239 = average(clipX(vtime('tran "/ea") (0.0004 + (714 * VAR("ramp"))) (0.0004 + (717 * VAR("ramp")))))
ea240 = average(clipX(vtime('tran "/ea") (0.0004 + (717 * VAR("ramp"))) (0.0004 + (720 * VAR("ramp")))))
ea241 = average(clipX(vtime('tran "/ea") (0.0004 + (720 * VAR("ramp"))) (0.0004 + (723 * VAR("ramp")))))
ea242 = average(clipX(vtime('tran "/ea") (0.0004 + (723 * VAR("ramp"))) (0.0004 + (726 * VAR("ramp")))))
ea243 = average(clipX(vtime('tran "/ea") (0.0004 + (726 * VAR("ramp"))) (0.0004 + (729 * VAR("ramp")))))
ea244 = average(clipX(vtime('tran "/ea") (0.0004 + (729 * VAR("ramp"))) (0.0004 + (732 * VAR("ramp")))))
ea245 = average(clipX(vtime('tran "/ea") (0.0004 + (732 * VAR("ramp"))) (0.0004 + (735 * VAR("ramp")))))
ea246 = average(clipX(vtime('tran "/ea") (0.0004 + (735 * VAR("ramp"))) (0.0004 + (738 * VAR("ramp")))))
ea247 = average(clipX(vtime('tran "/ea") (0.0004 + (738 * VAR("ramp"))) (0.0004 + (741 * VAR("ramp")))))
ea248 = average(clipX(vtime('tran "/ea") (0.0004 + (741 * VAR("ramp"))) (0.0004 + (744 * VAR("ramp")))))
ea249 = average(clipX(vtime('tran "/ea") (0.0004 + (744 * VAR("ramp"))) (0.0004 + (747 * VAR("ramp")))))
ea250 = average(clipX(vtime('tran "/ea") (0.0004 + (747 * VAR("ramp"))) (0.0004 + (750 * VAR("ramp")))))
ea251 = average(clipX(vtime('tran "/ea") (0.0004 + (750 * VAR("ramp"))) (0.0004 + (753 * VAR("ramp")))))
ea252 = average(clipX(vtime('tran "/ea") (0.0004 + (753 * VAR("ramp"))) (0.0004 + (756 * VAR("ramp")))))
ea253 = average(clipX(vtime('tran "/ea") (0.0004 + (756 * VAR("ramp"))) (0.0004 + (759 * VAR("ramp")))))
ea254 = average(clipX(vtime('tran "/ea") (0.0004 + (759 * VAR("ramp"))) (0.0004 + (762 * VAR("ramp")))))
ea255 = average(clipX(vtime('tran "/ea") (0.0004 + (762 * VAR("ramp"))) (0.0004 + (765 * VAR("ramp")))))
ea256 = average(clipX(vtime('tran "/ea") (0.0004 + (765 * VAR("ramp"))) (0.0004 + (768 * VAR("ramp")))))
ea257 = average(clipX(vtime('tran "/ea") (0.0004 + (768 * VAR("ramp"))) (0.0004 + (771 * VAR("ramp")))))
ea258 = average(clipX(vtime('tran "/ea") (0.0004 + (771 * VAR("ramp"))) (0.0004 + (774 * VAR("ramp")))))
ea259 = average(clipX(vtime('tran "/ea") (0.0004 + (774 * VAR("ramp"))) (0.0004 + (777 * VAR("ramp")))))
ea260 = average(clipX(vtime('tran "/ea") (0.0004 + (777 * VAR("ramp"))) (0.0004 + (780 * VAR("ramp")))))
ea261 = average(clipX(vtime('tran "/ea") (0.0004 + (780 * VAR("ramp"))) (0.0004 + (783 * VAR("ramp")))))
ea262 = average(clipX(vtime('tran "/ea") (0.0004 + (783 * VAR("ramp"))) (0.0004 + (786 * VAR("ramp")))))
ea263 = average(clipX(vtime('tran "/ea") (0.0004 + (786 * VAR("ramp"))) (0.0004 + (789 * VAR("ramp")))))
ea264 = average(clipX(vtime('tran "/ea") (0.0004 + (789 * VAR("ramp"))) (0.0004 + (792 * VAR("ramp")))))
ea265 = average(clipX(vtime('tran "/ea") (0.0004 + (792 * VAR("ramp"))) (0.0004 + (795 * VAR("ramp")))))
ea266 = average(clipX(vtime('tran "/ea") (0.0004 + (795 * VAR("ramp"))) (0.0004 + (798 * VAR("ramp")))))
ea267 = average(clipX(vtime('tran "/ea") (0.0004 + (798 * VAR("ramp"))) (0.0004 + (801 * VAR("ramp")))))
ea268 = average(clipX(vtime('tran "/ea") (0.0004 + (801 * VAR("ramp"))) (0.0004 + (804 * VAR("ramp")))))
ea269 = average(clipX(vtime('tran "/ea") (0.0004 + (804 * VAR("ramp"))) (0.0004 + (807 * VAR("ramp")))))
ea270 = average(clipX(vtime('tran "/ea") (0.0004 + (807 * VAR("ramp"))) (0.0004 + (810 * VAR("ramp")))))
ea271 = average(clipX(vtime('tran "/ea") (0.0004 + (810 * VAR("ramp"))) (0.0004 + (813 * VAR("ramp")))))
ea272 = average(clipX(vtime('tran "/ea") (0.0004 + (813 * VAR("ramp"))) (0.0004 + (816 * VAR("ramp")))))
ea273 = average(clipX(vtime('tran "/ea") (0.0004 + (816 * VAR("ramp"))) (0.0004 + (819 * VAR("ramp")))))
ea274 = average(clipX(vtime('tran "/ea") (0.0004 + (819 * VAR("ramp"))) (0.0004 + (822 * VAR("ramp")))))
ea275 = average(clipX(vtime('tran "/ea") (0.0004 + (822 * VAR("ramp"))) (0.0004 + (825 * VAR("ramp")))))
ea276 = average(clipX(vtime('tran "/ea") (0.0004 + (825 * VAR("ramp"))) (0.0004 + (828 * VAR("ramp")))))
ea277 = average(clipX(vtime('tran "/ea") (0.0004 + (828 * VAR("ramp"))) (0.0004 + (831 * VAR("ramp")))))
ea278 = average(clipX(vtime('tran "/ea") (0.0004 + (831 * VAR("ramp"))) (0.0004 + (834 * VAR("ramp")))))
ea279 = average(clipX(vtime('tran "/ea") (0.0004 + (834 * VAR("ramp"))) (0.0004 + (837 * VAR("ramp")))))
ea280 = average(clipX(vtime('tran "/ea") (0.0004 + (837 * VAR("ramp"))) (0.0004 + (840 * VAR("ramp")))))
ea281 = average(clipX(vtime('tran "/ea") (0.0004 + (840 * VAR("ramp"))) (0.0004 + (843 * VAR("ramp")))))
ea282 = average(clipX(vtime('tran "/ea") (0.0004 + (843 * VAR("ramp"))) (0.0004 + (846 * VAR("ramp")))))
ea283 = average(clipX(vtime('tran "/ea") (0.0004 + (846 * VAR("ramp"))) (0.0004 + (849 * VAR("ramp")))))
ea284 = average(clipX(vtime('tran "/ea") (0.0004 + (849 * VAR("ramp"))) (0.0004 + (852 * VAR("ramp")))))
ea285 = average(clipX(vtime('tran "/ea") (0.0004 + (852 * VAR("ramp"))) (0.0004 + (855 * VAR("ramp")))))
ea286 = average(clipX(vtime('tran "/ea") (0.0004 + (855 * VAR("ramp"))) (0.0004 + (858 * VAR("ramp")))))
ea287 = average(clipX(vtime('tran "/ea") (0.0004 + (858 * VAR("ramp"))) (0.0004 + (861 * VAR("ramp")))))
ea288 = average(clipX(vtime('tran "/ea") (0.0004 + (861 * VAR("ramp"))) (0.0004 + (864 * VAR("ramp")))))
ea289 = average(clipX(vtime('tran "/ea") (0.0004 + (864 * VAR("ramp"))) (0.0004 + (867 * VAR("ramp")))))
ea290 = average(clipX(vtime('tran "/ea") (0.0004 + (867 * VAR("ramp"))) (0.0004 + (870 * VAR("ramp")))))
ea291 = average(clipX(vtime('tran "/ea") (0.0004 + (870 * VAR("ramp"))) (0.0004 + (873 * VAR("ramp")))))
ea292 = average(clipX(vtime('tran "/ea") (0.0004 + (873 * VAR("ramp"))) (0.0004 + (876 * VAR("ramp")))))
ea293 = average(clipX(vtime('tran "/ea") (0.0004 + (876 * VAR("ramp"))) (0.0004 + (879 * VAR("ramp")))))
ea294 = average(clipX(vtime('tran "/ea") (0.0004 + (879 * VAR("ramp"))) (0.0004 + (882 * VAR("ramp")))))
ea295 = average(clipX(vtime('tran "/ea") (0.0004 + (882 * VAR("ramp"))) (0.0004 + (885 * VAR("ramp")))))
ea296 = average(clipX(vtime('tran "/ea") (0.0004 + (885 * VAR("ramp"))) (0.0004 + (888 * VAR("ramp")))))
ea297 = average(clipX(vtime('tran "/ea") (0.0004 + (888 * VAR("ramp"))) (0.0004 + (891 * VAR("ramp")))))
ea298 = average(clipX(vtime('tran "/ea") (0.0004 + (891 * VAR("ramp"))) (0.0004 + (894 * VAR("ramp")))))
ea299 = average(clipX(vtime('tran "/ea") (0.0004 + (894 * VAR("ramp"))) (0.0004 + (897 * VAR("ramp")))))
ea300 = average(clipX(vtime('tran "/ea") (0.0004 + (897 * VAR("ramp"))) (0.0004 + (900 * VAR("ramp")))))

ripple = peakToPeak(clipX(vtime('tran "/vo") (0.001336 - (30 * VAR("ramp"))) 0.001336))
Vo = average(clipX(vtime('tran "/vo") (0.001336 - (30 * VAR("ramp"))) 0.001336))
Pout = ((Vo * VAR("IL")) + ((Vo * Vo) / 1000))
Iin = average(clipX(IT("/V16/MINUS") (0.001336 - (30 * VAR("ramp"))) 0.001336))
Pin = (Iin * 5.5)
Id = average(clipX(IT("/V14/MINUS") (0.001336 - (30 * VAR("ramp"))) 0.001336))
Pd = (Id * 1.8)
eff = ((Pout / (Pin + Pd)) * 100)
Imin = ymin(clipX(IT("/V16/MINUS") (0.001336 - (30 * VAR("ramp"))) 0.001336))

port=outfile("/net/g/zzhou/pub/ML_HCR/hcrtestresult.txt" "a")
ocnPrint(?output port eff Vo ripple vc1 vc2 vc3 vc4 vc5 vc6 vc7 vc8 vc9 vc10 vc11 vc12 vc13 vc14 vc15 vc16 vc17 vc18 vc19 vc20 vc21 vc22 vc23 vc24 vc25 vc26 vc27 vc28 vc29 vc30 vc31 vc32 vc33 vc34 vc35 vc36 vc37 vc38 vc39 vc40 vc41 vc42 vc43 vc44 vc45 vc46 vc47 vc48 vc49 vc50 vc51 vc52 vc53 vc54 vc55 vc56 vc57 vc58 vc59 vc60 vc61 vc62 vc63 vc64 vc65 vc66 vc67 vc68 vc69 vc70 vc71 vc72 vc73 vc74 vc75 vc76 vc77 vc78 vc79 vc80 vc81 vc82 vc83 vc84 vc85 vc86 vc87 vc88 vc89 vc90 vc91 vc92 vc93 vc94 vc95 vc96 vc97 vc98 vc99 vc100 vc101 vc102 vc103 vc104 vc105 vc106 vc107 vc108 vc109 vc110 vc111 vc112 vc113 vc114 vc115 vc116 vc117 vc118 vc119 vc120 vc121 vc122 vc123 vc124 vc125 vc126 vc127 vc128 vc129 vc130 vc131 vc132 vc133 vc134 vc135 vc136 vc137 vc138 vc139 vc140 vc141 vc142 vc143 vc144 vc145 vc146 vc147 vc148 vc149 vc150 vc151 vc152 vc153 vc154 vc155 vc156 vc157 vc158 vc159 vc160 vc161 vc162 vc163 vc164 vc165 vc166 vc167 vc168 vc169 vc170 vc171 vc172 vc173 vc174 vc175 vc176 vc177 vc178 vc179 vc180 vc181 vc182 vc183 vc184 vc185 vc186 vc187 vc188 vc189 vc190 vc191 vc192 vc193 vc194 vc195 vc196 vc197 vc198 vc199 vc200 vc201 vc202 vc203 vc204 vc205 vc206 vc207 vc208 vc209 vc210 vc211 vc212 vc213 vc214 vc215 vc216 vc217 vc218 vc219 vc220 vc221 vc222 vc223 vc224 vc225 vc226 vc227 vc228 vc229 vc230 vc231 vc232 vc233 vc234 vc235 vc236 vc237 vc238 vc239 vc240 vc241 vc242 vc243 vc244 vc245 vc246 vc247 vc248 vc249 vc250 vc251 vc252 vc253 vc254 vc255 vc256 vc257 vc258 vc259 vc260 vc261 vc262 vc263 vc264 vc265 vc266 vc267 vc268 vc269 vc270 vc271 vc272 vc273 vc274 vc275 vc276 vc277 vc278 vc279 vc280 vc281 vc282 vc283 vc284 vc285 vc286 vc287 vc288 vc289 vc290 vc291 vc292 vc293 vc294 vc295 vc296 vc297 vc298 vc299 vc300 ea1 ea2 ea3 ea4 ea5 ea6 ea7 ea8 ea9 ea10 ea11 ea12 ea13 ea14 ea15 ea16 ea17 ea18 ea19 ea20 ea21 ea22 ea23 ea24 ea25 ea26 ea27 ea28 ea29 ea30 ea31 ea32 ea33 ea34 ea35 ea36 ea37 ea38 ea39 ea40 ea41 ea42 ea43 ea44 ea45 ea46 ea47 ea48 ea49 ea50 ea51 ea52 ea53 ea54 ea55 ea56 ea57 ea58 ea59 ea60 ea61 ea62 ea63 ea64 ea65 ea66 ea67 ea68 ea69 ea70 ea71 ea72 ea73 ea74 ea75 ea76 ea77 ea78 ea79 ea80 ea81 ea82 ea83 ea84 ea85 ea86 ea87 ea88 ea89 ea90 ea91 ea92 ea93 ea94 ea95 ea96 ea97 ea98 ea99 ea100 ea101 ea102 ea103 ea104 ea105 ea106 ea107 ea108 ea109 ea110 ea111 ea112 ea113 ea114 ea115 ea116 ea117 ea118 ea119 ea120 ea121 ea122 ea123 ea124 ea125 ea126 ea127 ea128 ea129 ea130 ea131 ea132 ea133 ea134 ea135 ea136 ea137 ea138 ea139 ea140 ea141 ea142 ea143 ea144 ea145 ea146 ea147 ea148 ea149 ea150 ea151 ea152 ea153 ea154 ea155 ea156 ea157 ea158 ea159 ea160 ea161 ea162 ea163 ea164 ea165 ea166 ea167 ea168 ea169 ea170 ea171 ea172 ea173 ea174 ea175 ea176 ea177 ea178 ea179 ea180 ea181 ea182 ea183 ea184 ea185 ea186 ea187 ea188 ea189 ea190 ea191 ea192 ea193 ea194 ea195 ea196 ea197 ea198 ea199 ea200 ea201 ea202 ea203 ea204 ea205 ea206 ea207 ea208 ea209 ea210 ea211 ea212 ea213 ea214 ea215 ea216 ea217 ea218 ea219 ea220 ea221 ea222 ea223 ea224 ea225 ea226 ea227 ea228 ea229 ea230 ea231 ea232 ea233 ea234 ea235 ea236 ea237 ea238 ea239 ea240 ea241 ea242 ea243 ea244 ea245 ea246 ea247 ea248 ea249 ea250 ea251 ea252 ea253 ea254 ea255 ea256 ea257 ea258 ea259 ea260 ea261 ea262 ea263 ea264 ea265 ea266 ea267 ea268 ea269 ea270 ea271 ea272 ea273 ea274 ea275 ea276 ea277 ea278 ea279 ea280 ea281 ea282 ea283 ea284 ea285 ea286 ea287 ea288 ea289 ea290 ea291 ea292 ea293 ea294 ea295 ea296 ea297 ea298 ea299 ea300 Imin)
close(port)
exit()
ocnCloseSession()
