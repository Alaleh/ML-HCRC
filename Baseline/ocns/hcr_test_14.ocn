simulator( 'spectre )
design(     "/net/g/zzhou/pub/ML_HCR/simulation/hcr_ml/fulltest_closeloop/maestro/results/maestro/.tmpADEDir_zzhou/hcr_ml_fulltest_closeloop_1/hcr_ml_fulltest_closeloop_schematic_spectre/netlist/netlist")
resultsDir( "/net/g/zzhou/pub/ML_HCR/simulation/results" )
modelFile(
    '("/net/ic/pdk/tsmc180/tsmc180_cmsp007/tsmc18/../models/spectre/cmn018_assp_v1d3.scs" "tt_dio_m")
    '("/net/ic/pdk/tsmc180/tsmc180_cmsp007/tsmc18/../models/spectre/cmn018_assp_v1d3.scs" "tt_dio_3m")
    '("/net/ic/pdk/tsmc180/tsmc180_cmsp007/tsmc18/../models/spectre/cmn018_assp_v1d3.scs" "tt_rtmom")
    '("/net/ic/pdk/tsmc180/tsmc180_cmsp007/tsmc18/../models/spectre/cmn018_assp_v1d3.scs" "tt_bbmvar")
    '("/net/ic/pdk/tsmc180/tsmc180_cmsp007/tsmc18/../models/spectre/cmn018_assp_v1d3.scs" "tt_disres")
    '("/net/ic/pdk/tsmc180/tsmc180_cmsp007/tsmc18/../models/spectre/cmn018_assp_v1d3.scs" "tt")
    '("/net/ic/pdk/tsmc180/tsmc180_cmsp007/tsmc18/../models/spectre/cmn018_assp_v1d3.scs" "tt_mim")
    '("/net/ic/pdk/tsmc180/tsmc180_cmsp007/tsmc18/../models/spectre/cmn018_assp_v1d3.scs" "tt_dio_dnw")
    '("/net/ic/pdk/tsmc180/tsmc180_cmsp007/tsmc18/../models/spectre/cmn018_assp_v1d3.scs" "tt_m")
    '("/net/ic/pdk/tsmc180/tsmc180_cmsp007/tsmc18/../models/spectre/cmn018_assp_v1d3.scs" "tt_3m")
    '("/net/ic/pdk/tsmc180/tsmc180_cmsp007/tsmc18/../models/spectre/cmn018_assp_v1d3.scs" "tt_ana33")
    '("/net/ic/pdk/tsmc180/tsmc180_cmsp007/tsmc18/../models/spectre/cmn018_assp_v1d3.scs" "tt_res")
    '("/net/ic/pdk/tsmc180/tsmc180_cmsp007/tsmc18/../models/spectre/cmn018_assp_v1d3.scs" "tt_bip3")
    '("/net/ic/pdk/tsmc180/tsmc180_cmsp007/tsmc18/../models/spectre/cmn018_assp_v1d3.scs" "tt_bip")
    '("/net/ic/pdk/tsmc180/tsmc180_cmsp007/tsmc18/../models/spectre/cmn018_assp_v1d3.scs" "tt_dio3")
    '("/net/ic/pdk/tsmc180/tsmc180_cmsp007/tsmc18/../models/spectre/cmn018_assp_v1d3.scs" "tt_3v")
    '("/net/ic/pdk/tsmc180/tsmc180_cmsp007/tsmc18/../models/spectre/cmn018_assp_v1d3.scs" "tt_dio")
    '("/net/ic/pdk/tsmc180/tsmc180_cmsp007/tsmc18/../models/spectre/cmn018_assp_v1d3.scs" "tt_na")
    '("/net/ic/pdk/tsmc180/tsmc180_cmsp007/tsmc18/../models/spectre/cmn018_assp_v1d3.scs" "tt_fmom")
    '("/net/ic/pdk/tsmc180/tsmc180_cmsp007/tsmc18/../models/spectre/cmn018_assp_v1d3.scs" "tt_3vna")
)
analysis('tran ?stop "0.0007744"  ?cmin "100f"  )
desVar(      "c1" 18.0u )
desVar(      "c2" 18.0u )
desVar(      "c3" 18.0u )
desVar(      "c4" 18.0u )
desVar(      "l" 1.5u )
desVar(      "f1" 20 )
desVar(      "f10" 20 )
desVar(      "f11" 20 )
desVar(      "f12" 20 )
desVar(      "f2" 20 )
desVar(      "f3" 20 )
desVar(      "f4" 20 )
desVar(      "f5" 20 )
desVar(      "f6" 20 )
desVar(      "f7" 20 )
desVar(      "f8" 20 )
desVar(      "f9" 20 )
desVar(      "m1" 120 )
desVar(      "m10" 120 )
desVar(      "m11" 120 )
desVar(      "m12" 120 )
desVar(      "m2" 120 )
desVar(      "m3" 120 )
desVar(      "m4" 120 )
desVar(      "m5" 120 )
desVar(      "m6" 120 )
desVar(      "m7" 120 )
desVar(      "m8" 120 )
desVar(      "m9" 120 )
desVar(      "trise" 30u    )
desVar(      "cpo" 700.0p )
desVar(      "cdr" 4n    )
desVar(      "co" 20u    )
desVar(      "ramp" 960.0n )
desVar(      "vref" 585.0m )
desVar(      "IL" 1000.0m )
envOption(
    'termDirectionMismatch  "ignore"
    'termMismatch  "ignore"
    'analysisOrder  list("tran" "pz" "dcmatch" "stb" "envlp" "ac" "dc" "lf" "noise" "xf" "sp" "pss" "pac" "pstb" "pnoise" "pxf" "psp" "qpss" "qpac" "qpnoise" "qpxf" "qpsp" "hb" "hbac" "hbstb" "hbnoise" "hbxf" "sens" "acmatch")
)
option(    'additionalArgs  "max_minstep_nonconv=5000"
    'pzSeverity  "None"
    'noiseSeverity  "None"
    'spSeverity  "None"
    'acSeverity  "None"
    'dcOpSeverity  "None"
    'dcSeverity  "None"
    'tranSeverity  "None"
    'multithread  "on"
)
option( ?categ 'turboOpts
    'disableVddOverride  nil
    'apsplus  t
    'errorLevel  "Liberal"
)
saveOption( ?outputParamInfo nil )
saveOption( ?elementInfo nil )
saveOption( ?modelParamInfo nil )
saveOption( ?simOutputFormat "psf" )
saveOption( ?infoOptions list(list("modelParameter" "models" "rawfile" "" "" "" nil) list("element" "inst" "rawfile" "" "" "" nil) list("outputParameter" "output" "rawfile" "" "" "" nil) list("designParamVals" "parameters" "rawfile" "" "" "" nil) list("primitives" "primitives" "rawfile" "" "" "" nil) list("subckts" "subckts" "rawfile" "" "" "" nil) list("asserts" "assert" "rawfile" "" "" "" nil) list("extremeinfo" "all" "logfile" "" "yes" "" nil) list("allcap" "allcap" "file" "" "" "" nil) list("<Click_To_Add>" "none" "rawfile" "" "" "" nil) ) )
saveOption( ?saveahdlvars "selected" )
saveOption( 'currents "selected" )
saveOption( 'pwr "none" )
saveOption( 'save "selected" )
save( 'v "/vo" "/ea" )
save( 'i "/V16/MINUS" "/V14/MINUS" )
converge( 'ic "/vo" "1" )
converge( 'ic "/net023" "1" )
converge( 'ic "/net094" "1" )
converge( 'ic "/4top" "1" )
converge( 'ic "/s23" "0" )
converge( 'ic "/s1" "0" )
converge( 'ic "/vref" "0" )
converge( 'ic "/net045" "1" )
converge( 'ic "/1top" "2" )
converge( 'ic "/a" "5.5" )
converge( 'ic "/2top" "5.5" )
temp( 27 )
run()
selectResult( 'tran )

vc1 = average(clipX(vtime('tran "/vo") (0.0004 + (0 * VAR("ramp"))) (0.0004 + (3 * VAR("ramp")))))
vc2 = average(clipX(vtime('tran "/vo") (0.0004 + (3 * VAR("ramp"))) (0.0004 + (6 * VAR("ramp")))))
vc3 = average(clipX(vtime('tran "/vo") (0.0004 + (6 * VAR("ramp"))) (0.0004 + (9 * VAR("ramp")))))
vc4 = average(clipX(vtime('tran "/vo") (0.0004 + (9 * VAR("ramp"))) (0.0004 + (12 * VAR("ramp")))))
vc5 = average(clipX(vtime('tran "/vo") (0.0004 + (12 * VAR("ramp"))) (0.0004 + (15 * VAR("ramp")))))
vc6 = average(clipX(vtime('tran "/vo") (0.0004 + (15 * VAR("ramp"))) (0.0004 + (18 * VAR("ramp")))))
vc7 = average(clipX(vtime('tran "/vo") (0.0004 + (18 * VAR("ramp"))) (0.0004 + (21 * VAR("ramp")))))
vc8 = average(clipX(vtime('tran "/vo") (0.0004 + (21 * VAR("ramp"))) (0.0004 + (24 * VAR("ramp")))))
vc9 = average(clipX(vtime('tran "/vo") (0.0004 + (24 * VAR("ramp"))) (0.0004 + (27 * VAR("ramp")))))
vc10 = average(clipX(vtime('tran "/vo") (0.0004 + (27 * VAR("ramp"))) (0.0004 + (30 * VAR("ramp")))))
vc11 = average(clipX(vtime('tran "/vo") (0.0004 + (30 * VAR("ramp"))) (0.0004 + (33 * VAR("ramp")))))
vc12 = average(clipX(vtime('tran "/vo") (0.0004 + (33 * VAR("ramp"))) (0.0004 + (36 * VAR("ramp")))))
vc13 = average(clipX(vtime('tran "/vo") (0.0004 + (36 * VAR("ramp"))) (0.0004 + (39 * VAR("ramp")))))
vc14 = average(clipX(vtime('tran "/vo") (0.0004 + (39 * VAR("ramp"))) (0.0004 + (42 * VAR("ramp")))))
vc15 = average(clipX(vtime('tran "/vo") (0.0004 + (42 * VAR("ramp"))) (0.0004 + (45 * VAR("ramp")))))
vc16 = average(clipX(vtime('tran "/vo") (0.0004 + (45 * VAR("ramp"))) (0.0004 + (48 * VAR("ramp")))))
vc17 = average(clipX(vtime('tran "/vo") (0.0004 + (48 * VAR("ramp"))) (0.0004 + (51 * VAR("ramp")))))
vc18 = average(clipX(vtime('tran "/vo") (0.0004 + (51 * VAR("ramp"))) (0.0004 + (54 * VAR("ramp")))))
vc19 = average(clipX(vtime('tran "/vo") (0.0004 + (54 * VAR("ramp"))) (0.0004 + (57 * VAR("ramp")))))
vc20 = average(clipX(vtime('tran "/vo") (0.0004 + (57 * VAR("ramp"))) (0.0004 + (60 * VAR("ramp")))))
vc21 = average(clipX(vtime('tran "/vo") (0.0004 + (60 * VAR("ramp"))) (0.0004 + (63 * VAR("ramp")))))
vc22 = average(clipX(vtime('tran "/vo") (0.0004 + (63 * VAR("ramp"))) (0.0004 + (66 * VAR("ramp")))))
vc23 = average(clipX(vtime('tran "/vo") (0.0004 + (66 * VAR("ramp"))) (0.0004 + (69 * VAR("ramp")))))
vc24 = average(clipX(vtime('tran "/vo") (0.0004 + (69 * VAR("ramp"))) (0.0004 + (72 * VAR("ramp")))))
vc25 = average(clipX(vtime('tran "/vo") (0.0004 + (72 * VAR("ramp"))) (0.0004 + (75 * VAR("ramp")))))
vc26 = average(clipX(vtime('tran "/vo") (0.0004 + (75 * VAR("ramp"))) (0.0004 + (78 * VAR("ramp")))))
vc27 = average(clipX(vtime('tran "/vo") (0.0004 + (78 * VAR("ramp"))) (0.0004 + (81 * VAR("ramp")))))
vc28 = average(clipX(vtime('tran "/vo") (0.0004 + (81 * VAR("ramp"))) (0.0004 + (84 * VAR("ramp")))))
vc29 = average(clipX(vtime('tran "/vo") (0.0004 + (84 * VAR("ramp"))) (0.0004 + (87 * VAR("ramp")))))
vc30 = average(clipX(vtime('tran "/vo") (0.0004 + (87 * VAR("ramp"))) (0.0004 + (90 * VAR("ramp")))))
vc31 = average(clipX(vtime('tran "/vo") (0.0004 + (90 * VAR("ramp"))) (0.0004 + (93 * VAR("ramp")))))
vc32 = average(clipX(vtime('tran "/vo") (0.0004 + (93 * VAR("ramp"))) (0.0004 + (96 * VAR("ramp")))))
vc33 = average(clipX(vtime('tran "/vo") (0.0004 + (96 * VAR("ramp"))) (0.0004 + (99 * VAR("ramp")))))
vc34 = average(clipX(vtime('tran "/vo") (0.0004 + (99 * VAR("ramp"))) (0.0004 + (102 * VAR("ramp")))))
vc35 = average(clipX(vtime('tran "/vo") (0.0004 + (102 * VAR("ramp"))) (0.0004 + (105 * VAR("ramp")))))
vc36 = average(clipX(vtime('tran "/vo") (0.0004 + (105 * VAR("ramp"))) (0.0004 + (108 * VAR("ramp")))))
vc37 = average(clipX(vtime('tran "/vo") (0.0004 + (108 * VAR("ramp"))) (0.0004 + (111 * VAR("ramp")))))
vc38 = average(clipX(vtime('tran "/vo") (0.0004 + (111 * VAR("ramp"))) (0.0004 + (114 * VAR("ramp")))))
vc39 = average(clipX(vtime('tran "/vo") (0.0004 + (114 * VAR("ramp"))) (0.0004 + (117 * VAR("ramp")))))
vc40 = average(clipX(vtime('tran "/vo") (0.0004 + (117 * VAR("ramp"))) (0.0004 + (120 * VAR("ramp")))))
vc41 = average(clipX(vtime('tran "/vo") (0.0004 + (120 * VAR("ramp"))) (0.0004 + (123 * VAR("ramp")))))
vc42 = average(clipX(vtime('tran "/vo") (0.0004 + (123 * VAR("ramp"))) (0.0004 + (126 * VAR("ramp")))))
vc43 = average(clipX(vtime('tran "/vo") (0.0004 + (126 * VAR("ramp"))) (0.0004 + (129 * VAR("ramp")))))
vc44 = average(clipX(vtime('tran "/vo") (0.0004 + (129 * VAR("ramp"))) (0.0004 + (132 * VAR("ramp")))))
vc45 = average(clipX(vtime('tran "/vo") (0.0004 + (132 * VAR("ramp"))) (0.0004 + (135 * VAR("ramp")))))
vc46 = average(clipX(vtime('tran "/vo") (0.0004 + (135 * VAR("ramp"))) (0.0004 + (138 * VAR("ramp")))))
vc47 = average(clipX(vtime('tran "/vo") (0.0004 + (138 * VAR("ramp"))) (0.0004 + (141 * VAR("ramp")))))
vc48 = average(clipX(vtime('tran "/vo") (0.0004 + (141 * VAR("ramp"))) (0.0004 + (144 * VAR("ramp")))))
vc49 = average(clipX(vtime('tran "/vo") (0.0004 + (144 * VAR("ramp"))) (0.0004 + (147 * VAR("ramp")))))
vc50 = average(clipX(vtime('tran "/vo") (0.0004 + (147 * VAR("ramp"))) (0.0004 + (150 * VAR("ramp")))))
vc51 = average(clipX(vtime('tran "/vo") (0.0004 + (150 * VAR("ramp"))) (0.0004 + (153 * VAR("ramp")))))
vc52 = average(clipX(vtime('tran "/vo") (0.0004 + (153 * VAR("ramp"))) (0.0004 + (156 * VAR("ramp")))))
vc53 = average(clipX(vtime('tran "/vo") (0.0004 + (156 * VAR("ramp"))) (0.0004 + (159 * VAR("ramp")))))
vc54 = average(clipX(vtime('tran "/vo") (0.0004 + (159 * VAR("ramp"))) (0.0004 + (162 * VAR("ramp")))))
vc55 = average(clipX(vtime('tran "/vo") (0.0004 + (162 * VAR("ramp"))) (0.0004 + (165 * VAR("ramp")))))
vc56 = average(clipX(vtime('tran "/vo") (0.0004 + (165 * VAR("ramp"))) (0.0004 + (168 * VAR("ramp")))))
vc57 = average(clipX(vtime('tran "/vo") (0.0004 + (168 * VAR("ramp"))) (0.0004 + (171 * VAR("ramp")))))
vc58 = average(clipX(vtime('tran "/vo") (0.0004 + (171 * VAR("ramp"))) (0.0004 + (174 * VAR("ramp")))))
vc59 = average(clipX(vtime('tran "/vo") (0.0004 + (174 * VAR("ramp"))) (0.0004 + (177 * VAR("ramp")))))
vc60 = average(clipX(vtime('tran "/vo") (0.0004 + (177 * VAR("ramp"))) (0.0004 + (180 * VAR("ramp")))))
vc61 = average(clipX(vtime('tran "/vo") (0.0004 + (180 * VAR("ramp"))) (0.0004 + (183 * VAR("ramp")))))
vc62 = average(clipX(vtime('tran "/vo") (0.0004 + (183 * VAR("ramp"))) (0.0004 + (186 * VAR("ramp")))))
vc63 = average(clipX(vtime('tran "/vo") (0.0004 + (186 * VAR("ramp"))) (0.0004 + (189 * VAR("ramp")))))
vc64 = average(clipX(vtime('tran "/vo") (0.0004 + (189 * VAR("ramp"))) (0.0004 + (192 * VAR("ramp")))))
vc65 = average(clipX(vtime('tran "/vo") (0.0004 + (192 * VAR("ramp"))) (0.0004 + (195 * VAR("ramp")))))
vc66 = average(clipX(vtime('tran "/vo") (0.0004 + (195 * VAR("ramp"))) (0.0004 + (198 * VAR("ramp")))))
vc67 = average(clipX(vtime('tran "/vo") (0.0004 + (198 * VAR("ramp"))) (0.0004 + (201 * VAR("ramp")))))
vc68 = average(clipX(vtime('tran "/vo") (0.0004 + (201 * VAR("ramp"))) (0.0004 + (204 * VAR("ramp")))))
vc69 = average(clipX(vtime('tran "/vo") (0.0004 + (204 * VAR("ramp"))) (0.0004 + (207 * VAR("ramp")))))
vc70 = average(clipX(vtime('tran "/vo") (0.0004 + (207 * VAR("ramp"))) (0.0004 + (210 * VAR("ramp")))))
vc71 = average(clipX(vtime('tran "/vo") (0.0004 + (210 * VAR("ramp"))) (0.0004 + (213 * VAR("ramp")))))
vc72 = average(clipX(vtime('tran "/vo") (0.0004 + (213 * VAR("ramp"))) (0.0004 + (216 * VAR("ramp")))))
vc73 = average(clipX(vtime('tran "/vo") (0.0004 + (216 * VAR("ramp"))) (0.0004 + (219 * VAR("ramp")))))
vc74 = average(clipX(vtime('tran "/vo") (0.0004 + (219 * VAR("ramp"))) (0.0004 + (222 * VAR("ramp")))))
vc75 = average(clipX(vtime('tran "/vo") (0.0004 + (222 * VAR("ramp"))) (0.0004 + (225 * VAR("ramp")))))
vc76 = average(clipX(vtime('tran "/vo") (0.0004 + (225 * VAR("ramp"))) (0.0004 + (228 * VAR("ramp")))))
vc77 = average(clipX(vtime('tran "/vo") (0.0004 + (228 * VAR("ramp"))) (0.0004 + (231 * VAR("ramp")))))
vc78 = average(clipX(vtime('tran "/vo") (0.0004 + (231 * VAR("ramp"))) (0.0004 + (234 * VAR("ramp")))))
vc79 = average(clipX(vtime('tran "/vo") (0.0004 + (234 * VAR("ramp"))) (0.0004 + (237 * VAR("ramp")))))
vc80 = average(clipX(vtime('tran "/vo") (0.0004 + (237 * VAR("ramp"))) (0.0004 + (240 * VAR("ramp")))))
vc81 = average(clipX(vtime('tran "/vo") (0.0004 + (240 * VAR("ramp"))) (0.0004 + (243 * VAR("ramp")))))
vc82 = average(clipX(vtime('tran "/vo") (0.0004 + (243 * VAR("ramp"))) (0.0004 + (246 * VAR("ramp")))))
vc83 = average(clipX(vtime('tran "/vo") (0.0004 + (246 * VAR("ramp"))) (0.0004 + (249 * VAR("ramp")))))
vc84 = average(clipX(vtime('tran "/vo") (0.0004 + (249 * VAR("ramp"))) (0.0004 + (252 * VAR("ramp")))))
vc85 = average(clipX(vtime('tran "/vo") (0.0004 + (252 * VAR("ramp"))) (0.0004 + (255 * VAR("ramp")))))
vc86 = average(clipX(vtime('tran "/vo") (0.0004 + (255 * VAR("ramp"))) (0.0004 + (258 * VAR("ramp")))))
vc87 = average(clipX(vtime('tran "/vo") (0.0004 + (258 * VAR("ramp"))) (0.0004 + (261 * VAR("ramp")))))
vc88 = average(clipX(vtime('tran "/vo") (0.0004 + (261 * VAR("ramp"))) (0.0004 + (264 * VAR("ramp")))))
vc89 = average(clipX(vtime('tran "/vo") (0.0004 + (264 * VAR("ramp"))) (0.0004 + (267 * VAR("ramp")))))
vc90 = average(clipX(vtime('tran "/vo") (0.0004 + (267 * VAR("ramp"))) (0.0004 + (270 * VAR("ramp")))))
vc91 = average(clipX(vtime('tran "/vo") (0.0004 + (270 * VAR("ramp"))) (0.0004 + (273 * VAR("ramp")))))
vc92 = average(clipX(vtime('tran "/vo") (0.0004 + (273 * VAR("ramp"))) (0.0004 + (276 * VAR("ramp")))))
vc93 = average(clipX(vtime('tran "/vo") (0.0004 + (276 * VAR("ramp"))) (0.0004 + (279 * VAR("ramp")))))
vc94 = average(clipX(vtime('tran "/vo") (0.0004 + (279 * VAR("ramp"))) (0.0004 + (282 * VAR("ramp")))))
vc95 = average(clipX(vtime('tran "/vo") (0.0004 + (282 * VAR("ramp"))) (0.0004 + (285 * VAR("ramp")))))
vc96 = average(clipX(vtime('tran "/vo") (0.0004 + (285 * VAR("ramp"))) (0.0004 + (288 * VAR("ramp")))))
vc97 = average(clipX(vtime('tran "/vo") (0.0004 + (288 * VAR("ramp"))) (0.0004 + (291 * VAR("ramp")))))
vc98 = average(clipX(vtime('tran "/vo") (0.0004 + (291 * VAR("ramp"))) (0.0004 + (294 * VAR("ramp")))))
vc99 = average(clipX(vtime('tran "/vo") (0.0004 + (294 * VAR("ramp"))) (0.0004 + (297 * VAR("ramp")))))
vc100 = average(clipX(vtime('tran "/vo") (0.0004 + (297 * VAR("ramp"))) (0.0004 + (300 * VAR("ramp")))))
vc101 = average(clipX(vtime('tran "/vo") (0.0004 + (300 * VAR("ramp"))) (0.0004 + (303 * VAR("ramp")))))
vc102 = average(clipX(vtime('tran "/vo") (0.0004 + (303 * VAR("ramp"))) (0.0004 + (306 * VAR("ramp")))))
vc103 = average(clipX(vtime('tran "/vo") (0.0004 + (306 * VAR("ramp"))) (0.0004 + (309 * VAR("ramp")))))
vc104 = average(clipX(vtime('tran "/vo") (0.0004 + (309 * VAR("ramp"))) (0.0004 + (312 * VAR("ramp")))))
vc105 = average(clipX(vtime('tran "/vo") (0.0004 + (312 * VAR("ramp"))) (0.0004 + (315 * VAR("ramp")))))
vc106 = average(clipX(vtime('tran "/vo") (0.0004 + (315 * VAR("ramp"))) (0.0004 + (318 * VAR("ramp")))))
vc107 = average(clipX(vtime('tran "/vo") (0.0004 + (318 * VAR("ramp"))) (0.0004 + (321 * VAR("ramp")))))
vc108 = average(clipX(vtime('tran "/vo") (0.0004 + (321 * VAR("ramp"))) (0.0004 + (324 * VAR("ramp")))))
vc109 = average(clipX(vtime('tran "/vo") (0.0004 + (324 * VAR("ramp"))) (0.0004 + (327 * VAR("ramp")))))
vc110 = average(clipX(vtime('tran "/vo") (0.0004 + (327 * VAR("ramp"))) (0.0004 + (330 * VAR("ramp")))))
vc111 = average(clipX(vtime('tran "/vo") (0.0004 + (330 * VAR("ramp"))) (0.0004 + (333 * VAR("ramp")))))
vc112 = average(clipX(vtime('tran "/vo") (0.0004 + (333 * VAR("ramp"))) (0.0004 + (336 * VAR("ramp")))))
vc113 = average(clipX(vtime('tran "/vo") (0.0004 + (336 * VAR("ramp"))) (0.0004 + (339 * VAR("ramp")))))
vc114 = average(clipX(vtime('tran "/vo") (0.0004 + (339 * VAR("ramp"))) (0.0004 + (342 * VAR("ramp")))))
vc115 = average(clipX(vtime('tran "/vo") (0.0004 + (342 * VAR("ramp"))) (0.0004 + (345 * VAR("ramp")))))
vc116 = average(clipX(vtime('tran "/vo") (0.0004 + (345 * VAR("ramp"))) (0.0004 + (348 * VAR("ramp")))))
vc117 = average(clipX(vtime('tran "/vo") (0.0004 + (348 * VAR("ramp"))) (0.0004 + (351 * VAR("ramp")))))
vc118 = average(clipX(vtime('tran "/vo") (0.0004 + (351 * VAR("ramp"))) (0.0004 + (354 * VAR("ramp")))))
vc119 = average(clipX(vtime('tran "/vo") (0.0004 + (354 * VAR("ramp"))) (0.0004 + (357 * VAR("ramp")))))
vc120 = average(clipX(vtime('tran "/vo") (0.0004 + (357 * VAR("ramp"))) (0.0004 + (360 * VAR("ramp")))))
vc121 = average(clipX(vtime('tran "/vo") (0.0004 + (360 * VAR("ramp"))) (0.0004 + (363 * VAR("ramp")))))
vc122 = average(clipX(vtime('tran "/vo") (0.0004 + (363 * VAR("ramp"))) (0.0004 + (366 * VAR("ramp")))))
vc123 = average(clipX(vtime('tran "/vo") (0.0004 + (366 * VAR("ramp"))) (0.0004 + (369 * VAR("ramp")))))
vc124 = average(clipX(vtime('tran "/vo") (0.0004 + (369 * VAR("ramp"))) (0.0004 + (372 * VAR("ramp")))))
vc125 = average(clipX(vtime('tran "/vo") (0.0004 + (372 * VAR("ramp"))) (0.0004 + (375 * VAR("ramp")))))
vc126 = average(clipX(vtime('tran "/vo") (0.0004 + (375 * VAR("ramp"))) (0.0004 + (378 * VAR("ramp")))))
vc127 = average(clipX(vtime('tran "/vo") (0.0004 + (378 * VAR("ramp"))) (0.0004 + (381 * VAR("ramp")))))
vc128 = average(clipX(vtime('tran "/vo") (0.0004 + (381 * VAR("ramp"))) (0.0004 + (384 * VAR("ramp")))))
vc129 = average(clipX(vtime('tran "/vo") (0.0004 + (384 * VAR("ramp"))) (0.0004 + (387 * VAR("ramp")))))
vc130 = average(clipX(vtime('tran "/vo") (0.0004 + (387 * VAR("ramp"))) (0.0004 + (390 * VAR("ramp")))))

ea1 = average(clipX(vtime('tran "/ea") (0.0004 + (0 * VAR("ramp"))) (0.0004 + (3 * VAR("ramp")))))
ea2 = average(clipX(vtime('tran "/ea") (0.0004 + (3 * VAR("ramp"))) (0.0004 + (6 * VAR("ramp")))))
ea3 = average(clipX(vtime('tran "/ea") (0.0004 + (6 * VAR("ramp"))) (0.0004 + (9 * VAR("ramp")))))
ea4 = average(clipX(vtime('tran "/ea") (0.0004 + (9 * VAR("ramp"))) (0.0004 + (12 * VAR("ramp")))))
ea5 = average(clipX(vtime('tran "/ea") (0.0004 + (12 * VAR("ramp"))) (0.0004 + (15 * VAR("ramp")))))
ea6 = average(clipX(vtime('tran "/ea") (0.0004 + (15 * VAR("ramp"))) (0.0004 + (18 * VAR("ramp")))))
ea7 = average(clipX(vtime('tran "/ea") (0.0004 + (18 * VAR("ramp"))) (0.0004 + (21 * VAR("ramp")))))
ea8 = average(clipX(vtime('tran "/ea") (0.0004 + (21 * VAR("ramp"))) (0.0004 + (24 * VAR("ramp")))))
ea9 = average(clipX(vtime('tran "/ea") (0.0004 + (24 * VAR("ramp"))) (0.0004 + (27 * VAR("ramp")))))
ea10 = average(clipX(vtime('tran "/ea") (0.0004 + (27 * VAR("ramp"))) (0.0004 + (30 * VAR("ramp")))))
ea11 = average(clipX(vtime('tran "/ea") (0.0004 + (30 * VAR("ramp"))) (0.0004 + (33 * VAR("ramp")))))
ea12 = average(clipX(vtime('tran "/ea") (0.0004 + (33 * VAR("ramp"))) (0.0004 + (36 * VAR("ramp")))))
ea13 = average(clipX(vtime('tran "/ea") (0.0004 + (36 * VAR("ramp"))) (0.0004 + (39 * VAR("ramp")))))
ea14 = average(clipX(vtime('tran "/ea") (0.0004 + (39 * VAR("ramp"))) (0.0004 + (42 * VAR("ramp")))))
ea15 = average(clipX(vtime('tran "/ea") (0.0004 + (42 * VAR("ramp"))) (0.0004 + (45 * VAR("ramp")))))
ea16 = average(clipX(vtime('tran "/ea") (0.0004 + (45 * VAR("ramp"))) (0.0004 + (48 * VAR("ramp")))))
ea17 = average(clipX(vtime('tran "/ea") (0.0004 + (48 * VAR("ramp"))) (0.0004 + (51 * VAR("ramp")))))
ea18 = average(clipX(vtime('tran "/ea") (0.0004 + (51 * VAR("ramp"))) (0.0004 + (54 * VAR("ramp")))))
ea19 = average(clipX(vtime('tran "/ea") (0.0004 + (54 * VAR("ramp"))) (0.0004 + (57 * VAR("ramp")))))
ea20 = average(clipX(vtime('tran "/ea") (0.0004 + (57 * VAR("ramp"))) (0.0004 + (60 * VAR("ramp")))))
ea21 = average(clipX(vtime('tran "/ea") (0.0004 + (60 * VAR("ramp"))) (0.0004 + (63 * VAR("ramp")))))
ea22 = average(clipX(vtime('tran "/ea") (0.0004 + (63 * VAR("ramp"))) (0.0004 + (66 * VAR("ramp")))))
ea23 = average(clipX(vtime('tran "/ea") (0.0004 + (66 * VAR("ramp"))) (0.0004 + (69 * VAR("ramp")))))
ea24 = average(clipX(vtime('tran "/ea") (0.0004 + (69 * VAR("ramp"))) (0.0004 + (72 * VAR("ramp")))))
ea25 = average(clipX(vtime('tran "/ea") (0.0004 + (72 * VAR("ramp"))) (0.0004 + (75 * VAR("ramp")))))
ea26 = average(clipX(vtime('tran "/ea") (0.0004 + (75 * VAR("ramp"))) (0.0004 + (78 * VAR("ramp")))))
ea27 = average(clipX(vtime('tran "/ea") (0.0004 + (78 * VAR("ramp"))) (0.0004 + (81 * VAR("ramp")))))
ea28 = average(clipX(vtime('tran "/ea") (0.0004 + (81 * VAR("ramp"))) (0.0004 + (84 * VAR("ramp")))))
ea29 = average(clipX(vtime('tran "/ea") (0.0004 + (84 * VAR("ramp"))) (0.0004 + (87 * VAR("ramp")))))
ea30 = average(clipX(vtime('tran "/ea") (0.0004 + (87 * VAR("ramp"))) (0.0004 + (90 * VAR("ramp")))))
ea31 = average(clipX(vtime('tran "/ea") (0.0004 + (90 * VAR("ramp"))) (0.0004 + (93 * VAR("ramp")))))
ea32 = average(clipX(vtime('tran "/ea") (0.0004 + (93 * VAR("ramp"))) (0.0004 + (96 * VAR("ramp")))))
ea33 = average(clipX(vtime('tran "/ea") (0.0004 + (96 * VAR("ramp"))) (0.0004 + (99 * VAR("ramp")))))
ea34 = average(clipX(vtime('tran "/ea") (0.0004 + (99 * VAR("ramp"))) (0.0004 + (102 * VAR("ramp")))))
ea35 = average(clipX(vtime('tran "/ea") (0.0004 + (102 * VAR("ramp"))) (0.0004 + (105 * VAR("ramp")))))
ea36 = average(clipX(vtime('tran "/ea") (0.0004 + (105 * VAR("ramp"))) (0.0004 + (108 * VAR("ramp")))))
ea37 = average(clipX(vtime('tran "/ea") (0.0004 + (108 * VAR("ramp"))) (0.0004 + (111 * VAR("ramp")))))
ea38 = average(clipX(vtime('tran "/ea") (0.0004 + (111 * VAR("ramp"))) (0.0004 + (114 * VAR("ramp")))))
ea39 = average(clipX(vtime('tran "/ea") (0.0004 + (114 * VAR("ramp"))) (0.0004 + (117 * VAR("ramp")))))
ea40 = average(clipX(vtime('tran "/ea") (0.0004 + (117 * VAR("ramp"))) (0.0004 + (120 * VAR("ramp")))))
ea41 = average(clipX(vtime('tran "/ea") (0.0004 + (120 * VAR("ramp"))) (0.0004 + (123 * VAR("ramp")))))
ea42 = average(clipX(vtime('tran "/ea") (0.0004 + (123 * VAR("ramp"))) (0.0004 + (126 * VAR("ramp")))))
ea43 = average(clipX(vtime('tran "/ea") (0.0004 + (126 * VAR("ramp"))) (0.0004 + (129 * VAR("ramp")))))
ea44 = average(clipX(vtime('tran "/ea") (0.0004 + (129 * VAR("ramp"))) (0.0004 + (132 * VAR("ramp")))))
ea45 = average(clipX(vtime('tran "/ea") (0.0004 + (132 * VAR("ramp"))) (0.0004 + (135 * VAR("ramp")))))
ea46 = average(clipX(vtime('tran "/ea") (0.0004 + (135 * VAR("ramp"))) (0.0004 + (138 * VAR("ramp")))))
ea47 = average(clipX(vtime('tran "/ea") (0.0004 + (138 * VAR("ramp"))) (0.0004 + (141 * VAR("ramp")))))
ea48 = average(clipX(vtime('tran "/ea") (0.0004 + (141 * VAR("ramp"))) (0.0004 + (144 * VAR("ramp")))))
ea49 = average(clipX(vtime('tran "/ea") (0.0004 + (144 * VAR("ramp"))) (0.0004 + (147 * VAR("ramp")))))
ea50 = average(clipX(vtime('tran "/ea") (0.0004 + (147 * VAR("ramp"))) (0.0004 + (150 * VAR("ramp")))))
ea51 = average(clipX(vtime('tran "/ea") (0.0004 + (150 * VAR("ramp"))) (0.0004 + (153 * VAR("ramp")))))
ea52 = average(clipX(vtime('tran "/ea") (0.0004 + (153 * VAR("ramp"))) (0.0004 + (156 * VAR("ramp")))))
ea53 = average(clipX(vtime('tran "/ea") (0.0004 + (156 * VAR("ramp"))) (0.0004 + (159 * VAR("ramp")))))
ea54 = average(clipX(vtime('tran "/ea") (0.0004 + (159 * VAR("ramp"))) (0.0004 + (162 * VAR("ramp")))))
ea55 = average(clipX(vtime('tran "/ea") (0.0004 + (162 * VAR("ramp"))) (0.0004 + (165 * VAR("ramp")))))
ea56 = average(clipX(vtime('tran "/ea") (0.0004 + (165 * VAR("ramp"))) (0.0004 + (168 * VAR("ramp")))))
ea57 = average(clipX(vtime('tran "/ea") (0.0004 + (168 * VAR("ramp"))) (0.0004 + (171 * VAR("ramp")))))
ea58 = average(clipX(vtime('tran "/ea") (0.0004 + (171 * VAR("ramp"))) (0.0004 + (174 * VAR("ramp")))))
ea59 = average(clipX(vtime('tran "/ea") (0.0004 + (174 * VAR("ramp"))) (0.0004 + (177 * VAR("ramp")))))
ea60 = average(clipX(vtime('tran "/ea") (0.0004 + (177 * VAR("ramp"))) (0.0004 + (180 * VAR("ramp")))))
ea61 = average(clipX(vtime('tran "/ea") (0.0004 + (180 * VAR("ramp"))) (0.0004 + (183 * VAR("ramp")))))
ea62 = average(clipX(vtime('tran "/ea") (0.0004 + (183 * VAR("ramp"))) (0.0004 + (186 * VAR("ramp")))))
ea63 = average(clipX(vtime('tran "/ea") (0.0004 + (186 * VAR("ramp"))) (0.0004 + (189 * VAR("ramp")))))
ea64 = average(clipX(vtime('tran "/ea") (0.0004 + (189 * VAR("ramp"))) (0.0004 + (192 * VAR("ramp")))))
ea65 = average(clipX(vtime('tran "/ea") (0.0004 + (192 * VAR("ramp"))) (0.0004 + (195 * VAR("ramp")))))
ea66 = average(clipX(vtime('tran "/ea") (0.0004 + (195 * VAR("ramp"))) (0.0004 + (198 * VAR("ramp")))))
ea67 = average(clipX(vtime('tran "/ea") (0.0004 + (198 * VAR("ramp"))) (0.0004 + (201 * VAR("ramp")))))
ea68 = average(clipX(vtime('tran "/ea") (0.0004 + (201 * VAR("ramp"))) (0.0004 + (204 * VAR("ramp")))))
ea69 = average(clipX(vtime('tran "/ea") (0.0004 + (204 * VAR("ramp"))) (0.0004 + (207 * VAR("ramp")))))
ea70 = average(clipX(vtime('tran "/ea") (0.0004 + (207 * VAR("ramp"))) (0.0004 + (210 * VAR("ramp")))))
ea71 = average(clipX(vtime('tran "/ea") (0.0004 + (210 * VAR("ramp"))) (0.0004 + (213 * VAR("ramp")))))
ea72 = average(clipX(vtime('tran "/ea") (0.0004 + (213 * VAR("ramp"))) (0.0004 + (216 * VAR("ramp")))))
ea73 = average(clipX(vtime('tran "/ea") (0.0004 + (216 * VAR("ramp"))) (0.0004 + (219 * VAR("ramp")))))
ea74 = average(clipX(vtime('tran "/ea") (0.0004 + (219 * VAR("ramp"))) (0.0004 + (222 * VAR("ramp")))))
ea75 = average(clipX(vtime('tran "/ea") (0.0004 + (222 * VAR("ramp"))) (0.0004 + (225 * VAR("ramp")))))
ea76 = average(clipX(vtime('tran "/ea") (0.0004 + (225 * VAR("ramp"))) (0.0004 + (228 * VAR("ramp")))))
ea77 = average(clipX(vtime('tran "/ea") (0.0004 + (228 * VAR("ramp"))) (0.0004 + (231 * VAR("ramp")))))
ea78 = average(clipX(vtime('tran "/ea") (0.0004 + (231 * VAR("ramp"))) (0.0004 + (234 * VAR("ramp")))))
ea79 = average(clipX(vtime('tran "/ea") (0.0004 + (234 * VAR("ramp"))) (0.0004 + (237 * VAR("ramp")))))
ea80 = average(clipX(vtime('tran "/ea") (0.0004 + (237 * VAR("ramp"))) (0.0004 + (240 * VAR("ramp")))))
ea81 = average(clipX(vtime('tran "/ea") (0.0004 + (240 * VAR("ramp"))) (0.0004 + (243 * VAR("ramp")))))
ea82 = average(clipX(vtime('tran "/ea") (0.0004 + (243 * VAR("ramp"))) (0.0004 + (246 * VAR("ramp")))))
ea83 = average(clipX(vtime('tran "/ea") (0.0004 + (246 * VAR("ramp"))) (0.0004 + (249 * VAR("ramp")))))
ea84 = average(clipX(vtime('tran "/ea") (0.0004 + (249 * VAR("ramp"))) (0.0004 + (252 * VAR("ramp")))))
ea85 = average(clipX(vtime('tran "/ea") (0.0004 + (252 * VAR("ramp"))) (0.0004 + (255 * VAR("ramp")))))
ea86 = average(clipX(vtime('tran "/ea") (0.0004 + (255 * VAR("ramp"))) (0.0004 + (258 * VAR("ramp")))))
ea87 = average(clipX(vtime('tran "/ea") (0.0004 + (258 * VAR("ramp"))) (0.0004 + (261 * VAR("ramp")))))
ea88 = average(clipX(vtime('tran "/ea") (0.0004 + (261 * VAR("ramp"))) (0.0004 + (264 * VAR("ramp")))))
ea89 = average(clipX(vtime('tran "/ea") (0.0004 + (264 * VAR("ramp"))) (0.0004 + (267 * VAR("ramp")))))
ea90 = average(clipX(vtime('tran "/ea") (0.0004 + (267 * VAR("ramp"))) (0.0004 + (270 * VAR("ramp")))))
ea91 = average(clipX(vtime('tran "/ea") (0.0004 + (270 * VAR("ramp"))) (0.0004 + (273 * VAR("ramp")))))
ea92 = average(clipX(vtime('tran "/ea") (0.0004 + (273 * VAR("ramp"))) (0.0004 + (276 * VAR("ramp")))))
ea93 = average(clipX(vtime('tran "/ea") (0.0004 + (276 * VAR("ramp"))) (0.0004 + (279 * VAR("ramp")))))
ea94 = average(clipX(vtime('tran "/ea") (0.0004 + (279 * VAR("ramp"))) (0.0004 + (282 * VAR("ramp")))))
ea95 = average(clipX(vtime('tran "/ea") (0.0004 + (282 * VAR("ramp"))) (0.0004 + (285 * VAR("ramp")))))
ea96 = average(clipX(vtime('tran "/ea") (0.0004 + (285 * VAR("ramp"))) (0.0004 + (288 * VAR("ramp")))))
ea97 = average(clipX(vtime('tran "/ea") (0.0004 + (288 * VAR("ramp"))) (0.0004 + (291 * VAR("ramp")))))
ea98 = average(clipX(vtime('tran "/ea") (0.0004 + (291 * VAR("ramp"))) (0.0004 + (294 * VAR("ramp")))))
ea99 = average(clipX(vtime('tran "/ea") (0.0004 + (294 * VAR("ramp"))) (0.0004 + (297 * VAR("ramp")))))
ea100 = average(clipX(vtime('tran "/ea") (0.0004 + (297 * VAR("ramp"))) (0.0004 + (300 * VAR("ramp")))))
ea101 = average(clipX(vtime('tran "/ea") (0.0004 + (300 * VAR("ramp"))) (0.0004 + (303 * VAR("ramp")))))
ea102 = average(clipX(vtime('tran "/ea") (0.0004 + (303 * VAR("ramp"))) (0.0004 + (306 * VAR("ramp")))))
ea103 = average(clipX(vtime('tran "/ea") (0.0004 + (306 * VAR("ramp"))) (0.0004 + (309 * VAR("ramp")))))
ea104 = average(clipX(vtime('tran "/ea") (0.0004 + (309 * VAR("ramp"))) (0.0004 + (312 * VAR("ramp")))))
ea105 = average(clipX(vtime('tran "/ea") (0.0004 + (312 * VAR("ramp"))) (0.0004 + (315 * VAR("ramp")))))
ea106 = average(clipX(vtime('tran "/ea") (0.0004 + (315 * VAR("ramp"))) (0.0004 + (318 * VAR("ramp")))))
ea107 = average(clipX(vtime('tran "/ea") (0.0004 + (318 * VAR("ramp"))) (0.0004 + (321 * VAR("ramp")))))
ea108 = average(clipX(vtime('tran "/ea") (0.0004 + (321 * VAR("ramp"))) (0.0004 + (324 * VAR("ramp")))))
ea109 = average(clipX(vtime('tran "/ea") (0.0004 + (324 * VAR("ramp"))) (0.0004 + (327 * VAR("ramp")))))
ea110 = average(clipX(vtime('tran "/ea") (0.0004 + (327 * VAR("ramp"))) (0.0004 + (330 * VAR("ramp")))))
ea111 = average(clipX(vtime('tran "/ea") (0.0004 + (330 * VAR("ramp"))) (0.0004 + (333 * VAR("ramp")))))
ea112 = average(clipX(vtime('tran "/ea") (0.0004 + (333 * VAR("ramp"))) (0.0004 + (336 * VAR("ramp")))))
ea113 = average(clipX(vtime('tran "/ea") (0.0004 + (336 * VAR("ramp"))) (0.0004 + (339 * VAR("ramp")))))
ea114 = average(clipX(vtime('tran "/ea") (0.0004 + (339 * VAR("ramp"))) (0.0004 + (342 * VAR("ramp")))))
ea115 = average(clipX(vtime('tran "/ea") (0.0004 + (342 * VAR("ramp"))) (0.0004 + (345 * VAR("ramp")))))
ea116 = average(clipX(vtime('tran "/ea") (0.0004 + (345 * VAR("ramp"))) (0.0004 + (348 * VAR("ramp")))))
ea117 = average(clipX(vtime('tran "/ea") (0.0004 + (348 * VAR("ramp"))) (0.0004 + (351 * VAR("ramp")))))
ea118 = average(clipX(vtime('tran "/ea") (0.0004 + (351 * VAR("ramp"))) (0.0004 + (354 * VAR("ramp")))))
ea119 = average(clipX(vtime('tran "/ea") (0.0004 + (354 * VAR("ramp"))) (0.0004 + (357 * VAR("ramp")))))
ea120 = average(clipX(vtime('tran "/ea") (0.0004 + (357 * VAR("ramp"))) (0.0004 + (360 * VAR("ramp")))))
ea121 = average(clipX(vtime('tran "/ea") (0.0004 + (360 * VAR("ramp"))) (0.0004 + (363 * VAR("ramp")))))
ea122 = average(clipX(vtime('tran "/ea") (0.0004 + (363 * VAR("ramp"))) (0.0004 + (366 * VAR("ramp")))))
ea123 = average(clipX(vtime('tran "/ea") (0.0004 + (366 * VAR("ramp"))) (0.0004 + (369 * VAR("ramp")))))
ea124 = average(clipX(vtime('tran "/ea") (0.0004 + (369 * VAR("ramp"))) (0.0004 + (372 * VAR("ramp")))))
ea125 = average(clipX(vtime('tran "/ea") (0.0004 + (372 * VAR("ramp"))) (0.0004 + (375 * VAR("ramp")))))
ea126 = average(clipX(vtime('tran "/ea") (0.0004 + (375 * VAR("ramp"))) (0.0004 + (378 * VAR("ramp")))))
ea127 = average(clipX(vtime('tran "/ea") (0.0004 + (378 * VAR("ramp"))) (0.0004 + (381 * VAR("ramp")))))
ea128 = average(clipX(vtime('tran "/ea") (0.0004 + (381 * VAR("ramp"))) (0.0004 + (384 * VAR("ramp")))))
ea129 = average(clipX(vtime('tran "/ea") (0.0004 + (384 * VAR("ramp"))) (0.0004 + (387 * VAR("ramp")))))
ea130 = average(clipX(vtime('tran "/ea") (0.0004 + (387 * VAR("ramp"))) (0.0004 + (390 * VAR("ramp")))))

ripple = peakToPeak(clipX(vtime('tran "/vo") (0.0007744 - (30 * VAR("ramp"))) 0.0007744))
Vo = average(clipX(vtime('tran "/vo") (0.0007744 - (30 * VAR("ramp"))) 0.0007744))
Pout = ((Vo * VAR("IL")) + ((Vo * Vo) / 1000))
Iin = average(clipX(IT("/V16/MINUS") (0.0007744 - (30 * VAR("ramp"))) 0.0007744))
Pin = (Iin * 5.5)
Id = average(clipX(IT("/V14/MINUS") (0.0007744 - (30 * VAR("ramp"))) 0.0007744))
Pd = (Id * 1.8)
eff = ((Pout / (Pin + Pd)) * 100)
Imin = ymin(clipX(IT("/V16/MINUS") (0.0007744 - (30 * VAR("ramp"))) 0.0007744))

port=outfile("/net/g/zzhou/pub/ML_HCR/Baseline/hcrtestresult.txt" "a")
ocnPrint(?output port eff Vo ripple vc1 vc2 vc3 vc4 vc5 vc6 vc7 vc8 vc9 vc10 vc11 vc12 vc13 vc14 vc15 vc16 vc17 vc18 vc19 vc20 vc21 vc22 vc23 vc24 vc25 vc26 vc27 vc28 vc29 vc30 vc31 vc32 vc33 vc34 vc35 vc36 vc37 vc38 vc39 vc40 vc41 vc42 vc43 vc44 vc45 vc46 vc47 vc48 vc49 vc50 vc51 vc52 vc53 vc54 vc55 vc56 vc57 vc58 vc59 vc60 vc61 vc62 vc63 vc64 vc65 vc66 vc67 vc68 vc69 vc70 vc71 vc72 vc73 vc74 vc75 vc76 vc77 vc78 vc79 vc80 vc81 vc82 vc83 vc84 vc85 vc86 vc87 vc88 vc89 vc90 vc91 vc92 vc93 vc94 vc95 vc96 vc97 vc98 vc99 vc100 vc101 vc102 vc103 vc104 vc105 vc106 vc107 vc108 vc109 vc110 vc111 vc112 vc113 vc114 vc115 vc116 vc117 vc118 vc119 vc120 vc121 vc122 vc123 vc124 vc125 vc126 vc127 vc128 vc129 vc130 ea1 ea2 ea3 ea4 ea5 ea6 ea7 ea8 ea9 ea10 ea11 ea12 ea13 ea14 ea15 ea16 ea17 ea18 ea19 ea20 ea21 ea22 ea23 ea24 ea25 ea26 ea27 ea28 ea29 ea30 ea31 ea32 ea33 ea34 ea35 ea36 ea37 ea38 ea39 ea40 ea41 ea42 ea43 ea44 ea45 ea46 ea47 ea48 ea49 ea50 ea51 ea52 ea53 ea54 ea55 ea56 ea57 ea58 ea59 ea60 ea61 ea62 ea63 ea64 ea65 ea66 ea67 ea68 ea69 ea70 ea71 ea72 ea73 ea74 ea75 ea76 ea77 ea78 ea79 ea80 ea81 ea82 ea83 ea84 ea85 ea86 ea87 ea88 ea89 ea90 ea91 ea92 ea93 ea94 ea95 ea96 ea97 ea98 ea99 ea100 ea101 ea102 ea103 ea104 ea105 ea106 ea107 ea108 ea109 ea110 ea111 ea112 ea113 ea114 ea115 ea116 ea117 ea118 ea119 ea120 ea121 ea122 ea123 ea124 ea125 ea126 ea127 ea128 ea129 ea130 Imin)
close(port)
exit()
ocnCloseSession()
